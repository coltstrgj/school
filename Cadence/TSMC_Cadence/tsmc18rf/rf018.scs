//
//  **********************************************
simulator lang=spectre
// **********************************************
// *             TSMC RF SPICE MODEL            *
// **********************************************
// This model has been modified for RF purppose.
//
//     PROCESS :  0.18um Mixed-Signal SALICIDE(1P6M+, 1.8V/3.3V)
//     MODEL   :  BSIM3 ( V3.24 )
//     DOC. NO.:  T-018-MM-SP-001
//     VERSION :  1.3
//     DATE    :  Aug. 19, 2004
//    SPECTRE VERSION : 50 MSR
//
//  *****************************************************************************
//
// *
//   THIS MODEL LIB CONTAINS RF MODEL and BASEBAND model :
// *
//
// *
//    A. RF model contains:
// *
//
// *
//        1. 1.8V nominal Vt N/PMOS corner
// *
//
// *
//           a.LIB TT_RFMOS:Typical RF model
// *
//
// *
//           b.LIB FF_RFMOS:Fast N Fast P corner RF model
// *
//
// *
//           c.LIB SS_RFMOS:Slow N Slow P corner RF model
// *
//
// *
//           d.LIB SF_RFMOS:Slow N Fast P corner RF model
// *
//
// *
//           e.LIB FS_RFMOS:Fast N Slow P corner RF model
// *
//
// *
//           f.LIB MC_RFMOS:Monte-Carlo RF statistical model
// *
//
// *
//        2. 3.3V nominal Vt N/PMOS corner
// *
//
// *
//           a.LIB TT_RFMOS33:Typical RF model
// *
//
// *
//           b.LIB FF_RFMOS33:Fast N Fast P corner RF model
// *
//
// *
//           c.LIB SS_RFMOS33:Slow N Slow P corner RF model
// *
//
// *
//           d.LIB SF_RFMOS33:Slow N Fast P corner RF model
// *
//
// *
//           e.LIB FS_RFMOS33:Fast N Slow P corner RF model
// *
//
// *
//           f.LIB MC_RFMOS33:Monte-Carlo RF statistical model
// *
//
// *
//        3. MIM capacitor corner model
// *
//
// *
//           a.LIB TT_rfMIM:Typical model
// *
//
// *
//           b.LIB FF_rfMIM:Fast corner model
// *
//
// *
//           c.LIB SS_rfMIM:Slow corner model
// *
//
// *
//
// *
//        4. Inductor corner model
// *
//
// *
//           a.LIB TT_rfIND:Typical model
// *
//
// *
//           b.LIB FF_rfIND:Fast corner model
// *
//
// *
//           c.LIB SS_rfIND:Slow corner model
// *
//
// *
//
// *
//        5. 1.8V/3.3V MOS varactor corner model
// *
//
// *
//           a.LIB TT_rfMVAR:Typical model
// *
//
// *
//           b.LIB FF_rfMVAR:Fast corner model
// *
//
// *
//           c.LIB SS_rfMVAR:Slow corner model
// *
//
// *
//
// *
//        6. P+/NW Junction varactor corner model
// *
//
// *
//           a.LIB TT_rfJVAR:Typical model
// *
//
// *
//           b.LIB FF_rfJVAR:Fast corner model
// *
//
// *
//           c.LIB SS_rfJVAR:Slow corner model
// *
//
// *
//
// *
//        7. Resistor corner model
// *
//
// *
//           a. Salicided poly resistor
// *
//
// *
//              (a).LIB TT_rfRES_SA:Typical model
// *
//
// *
//              (b).LIB FF_rfRES_SA:Fast corner model
// *
//
// *
//              (c).LIB SS_rfRES_SA:Slow corner model
// *
//
// *
//           b. Non-salicided poly resistor
// *
//
// *
//              (a).LIB TT_rfRES_RPO:Typical model
// *
//
// *
//              (b).LIB FF_rfRES_RPO:Fast corner model
// *
//
// *
//              (c).LIB SS_rfRES_RPO:Slow corner model
// *
//
// *
//           c. HRI P- poly resistor
// *
//
// *
//              (a).LIB TT_rfRES_HRI:Typical model
// *
//
// *
//              (b).LIB FF_rfRES_HRI:Fast corner model
// *
//
// *
//              (c).LIB SS_rfRES_HRI:Slow corner model
// *
//
// *
//        8. Low capasitance ESD corner model
// *
//
// *
//           a.LIB TT_rfESD:Typical model
// *
//
// *
//           b.LIB FF_rfESD:Fast corner model
// *
//
// *
//           c.LIB SS_rfESD:Slow corner model
// *
// *
//
// *
//
// *
//    B. BASEBAND model contains:
// *
//
// *
//        1.LIB TT
// *
//              SS
// *
//              FF
// *
//              SF
// *
//              FS
// *
//              MC : for Monte-Carlo statistical model
// *
//          Model name    length range         width range     unit
// *
//                        low     high         low    high
// *
//           ----------------------------------------------------------
// *
//             nch        0.18  20.0           0.22    900      um
// *
//           ----------------------------------------------------------
// *
//             pch        0.18  20.0           0.22    900      um
// *
//           ----------------------------------------------------------
// *
//         ( 1.8V Normal devices with different geometric and corner models)
// *
//
// *
//        2.LIB TT_3V
// *
//              SS_3V
// *
//              FF_3V
// *
//              SF_3V
// *
//              FS_3V
// *
//              MC_3V : for Monte-Carlo statistical model
// *
//          Model name    length range         width range     unit
// *
//                        low     high         low    high
// *
//           ----------------------------------------------------------
// *
//             nch3       0.35  20.0           0.22    900      um
// *
//             pch3       0.30  20.0           0.22    900      um
// *
//           ----------------------------------------------------------
// *
//         ( 3.3V normal devices  with different
// *
//           geometric and corner models)
// *
//
// *
//        3.LIB TT_NA
// *
//              SS_NA
// *
//              FF_NA
// *
//              SF_NA
// *
//              FS_NA
// *
//          Model name    length range         width range     unit
// *
//                        low     high         low    high
// *
//           ----------------------------------------------------------
// *
//             nanch      0.5   20.0           0.22    100      um
// *
//           ----------------------------------------------------------
// *
//         ( 1.8V native NMOS with different geometric and corner models)
// *
//
// *
//        4.LIB TT_3VNA
// *
//              SS_3VNA
// *
//              FF_3VNA
// *
//              SF_3VNA
// *
//              FS_3VNA
// *
//          Model name    length range         width range     unit
// *
//                        low     high         low    high
// *
//           ----------------------------------------------------------
// *
//             nanch3     1.2   20.0           0.22    100      um
// *
//           ----------------------------------------------------------
// *
//         ( 3.3V native NMOS with different geometric and corner models)
// *
//
// *
//        5.LIB TT_M
// *
//              SS_M
// *
//              FF_M
// *
//              SF_M
// *
//              FS_M
// *
//          Model name    length range         width range     unit
// *
//                        low     high         low    high
// *
//           ----------------------------------------------------------
// *
//             mench      0.30  10.0           0.22    100      um
// *
//             mepch      0.25  10.0           0.22    100      um
// *
//           ----------------------------------------------------------
// *
//         ( 1.8V Medium Vt devices with different geometric and corner models)
// *
//
// *
//        6.LIB TT_3M
// *
//              SS_3M
// *
//              FF_3M
// *
//              SF_3M
// *
//              FS_3M
// *
//          Model name    length range         width range     unit
// *
//                        low     high         low    high
// *
//           ----------------------------------------------------------
// *
//             mench3     0.6   10.0           0.22    100      um
// *
//           ----------------------------------------------------------
// *
//         ( 3.3V Medium Vt NMOS with different geometric and corner models)
// *
//
// *
//        7.LIB TT_BIP
// *
//              SS_BIP
// *
//              FF_BIP
// *
//             Model name      emitter area      base area         unit
// *
//           ------------------------------------------------------------
// *
//               pnp10            10x10            16x16           um^2
// *
//               pnp5              5x5             11x11           um^2
// *
//               pnp2              2x2              8x8            um^2
// *
//               npn10            10x10            16x16           um^2
// *
//               npn5              5x5             11x11           um^2
// *
//               npn2              2x2              8x8            um^2
// *
//           ------------------------------------------------------------
// *
//         ( 1.8V P+/NW/PSUB 10x10, 5x5 and 2x2 vertical PNP bipolar and
// *
//                N+/PW/DNW  10x10, 5x5  and 2x2 vertical NPN bipolar )
// *
//
// *
//        8.LIB TT_BIP3
// *
//              SS_BIP3
// *
//              FF_BIP3
// *
//             Model name      emitter area      base area         unit
// *
//           ------------------------------------------------------------
// *
//               pnp10_3          10x10            16x16           um^2
// *
//               pnp5_3            5x5             11x11           um^2
// *
//               pnp2_3            2x2              8x8            um^2
// *
//           ------------------------------------------------------------
// *
//         ( 3.3V P+/NW/PSUB 10x10, 5x5 and 2x2 vertical PNP bipolar )
// *
//
// *
//        9.LIB DIO
// *
//         ( 1.8V P+/NW , N+/PW & NW/PSUB diode )
// *
//
// *
//       10.LIB DIO3
// *
//         ( 3.3V P+/NW , N+/PW & NW/PSUB diode )
// *
//
// *
//       11.LIB DIO_DNW
// *
//         ( DNWPSUB & PWDNW diode )
// *
//
// *
//       12.LIB RES
// *
//          (resist model)
// *
//  Model name      structure
// *
//  -----------------------------------------
// *
//   rnod         N+diff w/i silicide W>2um
// *
//   rnodw        N+diff w/i silicide 0.22um<W<2um
// *
//   rpod         P+diff w/i silicide W>2um
// *
//   rpodw        P+diff w/i silicide 0.22um<W<2um
// *
//   rnodrpo      N+diff w/o silicide 2um<=W
// *
//   rpodrpo      P+diff w/o silicide 2um<=W
// *
//   rnwod        NW diff(under OD)
// *
//   rnwsti       NW diff(under STI)
// *
//   rnpo1        N+Poly w/i silicide W>2um
// *
//   rnpow        N+Poly w/i silicide 0.18um<W<2um
// *
//   rppo1        P+Poly w/i silicide W>2um
// *
//   rppow        P+Poly w/i silicide 0.18um<W<2um
// *
//   rnpo1rpo     N+Poly w/o silicide 2um<W
// *
//   rppo1rpo     P+Poly w/o silicide 2um<W
// *
//   rm1          Metal 1 with W/S=0.23/0.23
// *
//   rm2~5        Metal 2 to 5 with W/S=0.28/0.28
// *
//   rm6          Metal 6 with W/S=0.44/0.46
// *
//   rppolyhri    P-Poly w/o silicide 2um<W
// *
//   rnpo1_dis    Distribute N+Poly w/i silicide W>2um
// *
//   rnpow_dis    Distribute N+Poly w/i silicide 0.18um<W<2um
// *
//   rppo1_dis    Distribute P+Poly w/i silicide W>2um
// *
//   rppow_dis    Distribute P+Poly w/i silicide 0.18um<W<2um
// *
//   rnpo1rpo_dis Distribute N+Poly w/o silicide 2um<W
// *
//   rppo1rpo_dis Distribute P+Poly w/o silicide 2um<W
// *
//   rppolyhri_dis Distribute P-Poly w/o silicide 2um<W

// *
//
// *
//       13.TT_MiM
//          FF_MiM
//          SS_MiM
// *
//         ( MiM Capacitance model )
// *
//       14.TT_BBMVAR
//          FF_BBMVAR
//          SS_BBMVAR
// *
//         ( MOS Varactor model )
// *
//
// *
//  *****************************************************************************
//                                                                             *
//  *****************************************************************************
//
//  1)To use RF models directly by programming in this style:
//
//      .lib 'lib_path/lib_name' xx_rfyyy          (xx represents TT, FF or SS)
//      .lib 'lib_path/lib_name' xx_rfyyy          (yyy represents MOS, BJT, MIM,
//      .lib 'lib_path/lib_name' xx_rfyyy           IND, MVAR, JVAR, RES_SA,
//                    .                             RES_RPO and RES_HRI)
//                    .
//                    .
//
//   EX:  .lib '/home/user/tsmc/LOGIC/rf018.l' TT_rfMOS
//        .lib '/home/user/tsmc/LOGIC/rf018.l' FF_rfMIM
//        .lib '/home/user/tsmc/LOGIC/rf018.l' SS_rfIND
//        .lib '/home/user/tsmc/LOGIC/rf018.l' TT_rfRES_SA
//
//   for typical MOS, fast MIM, slow inductor and typical salicided resistor model
//
//  2)To use baseand models directly by programming in this style:
//
//
//      .lib 'lib_path/lib_name' model_name
//                                                                            *
//
//     EX: .lib '/home/user/tsmc/LOGIC/rf018.l' TT
//         for typical 1.8V N,PMOS
//         .lib '/home/user/tsmc/LOGIC/rf018.l' TT_3V
//         for typical 3.3V N,PMOS
//   note:
//       corner_name
//        TT : typical model for 1.8V devices
//        SS : Slow NMOS Slow PMOS model for 1.8V devices
//        FF : Fast NMOS Fast PMOS model for 1.8V devices
//        SF : Slow NMOS Fast PMOS model for 1.8V devices
//        FS : Fast NMOS Slow PMOS model for 1.8V devices
//        MC : Statistical model for 1.8V devices
//
//        TT_3V : typical model for 3.3V devices
//        SS_3V : Slow NMOS Slow PMOS model for 3.3V devices
//        FF_3V : Fast NMOS Fast PMOS model for 3.3V devices
//        SF_3V : Slow NMOS Fast PMOS model for 3.3V devices
//        FS_3V : Fast NMOS Slow PMOS model for 3.3V devices
//        MC_3V : Statistical model for 3.3V devices
//
//        TT_NA : typical model for 1.8V native NMOS
//        SS_NA : Slow NMOS for 1.8V native NMOS
//        FF_NA : Fast NMOS for 1.8V native NMOS
//        SF_NA : Slow NMOS for 1.8V native NMOS
//        FS_NA : Fast NMOS for 1.8V native NMOS
//
//        TT_3VNA : typical model for 3.3V native NMOS
//        SS_3VNA : Slow NMOS for 3.3V native NMOS
//        FF_3VNA : Fast NMOS for 3.3V native NMOS
//        SF_3VNA : Slow NMOS for 3.3V native NMOS
//        FS_3VNA : Fast NMOS for 3.3V native NMOS
//
//  3)HDIF depends on your layout poly spacer to contact center distance.
//    The value listed here is TSMC minimum-rule value. You can change it
//    according to your layout.
//
//
//
//
//  ******************************************************
//  *******    1.8V N/PMOS Corner Parameters   ***********
//  ******************************************************

library tsmclib
section tt_rfmos

parameters a1n_rf=0
parameters a1p_rf=0
parameters a2np_rf=0
parameters a3np_rf=0
parameters a4np_rf=0
parameters vthnmis_rf=0
parameters dlnmis_rf=0
parameters dwnmis_rf=0
parameters toxnmis_rf=0
parameters vthpmis_rf=0
parameters dlpmis_rf=0
parameters dwpmis_rf=0
parameters toxpmis_rf=0
parameters fac_n_rf=0.3766 * 2.4
parameters fac_p_rf=0.3766 * 2.1
parameters du0n_rf=a1n_rf * fac_n_rf * ( - 0.2e-2)
parameters dlu0n_rf=a1n_rf * fac_n_rf * ( - 0.5e-9)
parameters dwu0n_rf=a1n_rf * fac_n_rf * ( - 0.00e-9)
parameters dpu0n_rf=a1n_rf * fac_n_rf * ( - 0.0e-16)
parameters dvthn_rf=a1n_rf * fac_n_rf * 0.0205
parameters dlvthn_rf=a1n_rf * fac_n_rf * 2.9e-9
parameters dwvthn_rf=a1n_rf * fac_n_rf * 6.60e-9
parameters dpvthn_rf=a1n_rf * fac_n_rf * 3.0e-15
parameters toxn_rf=4.08e-09 + a4np_rf * fac_n_rf * 1.33e-10 * 0.5
parameters dxln_rf=a2np_rf * fac_n_rf * 1.33e-8 * 0.5
parameters dxwn_rf=a3np_rf * fac_n_rf * 2.2e-8 * 0.5
parameters dk2n_rf=a1n_rf * fac_n_rf * 0.008
parameters dlk2n_rf=a1n_rf * fac_n_rf * 0.4e-8
parameters dvsatn_rf= - a1n_rf * fac_n_rf * 0.4e4
parameters dwvsatn_rf= - a1n_rf * fac_n_rf * 0.0e-3
parameters deta0n_rf=0.0 * a1n_rf * fac_n_rf
parameters dleta0n_rf= - 0.35e-9 * 0.5 * (a1n_rf * fac_n_rf - sqrt(a1n_rf * fac_n_rf
+ * a1n_rf * fac_n_rf + 1e-8))
parameters dweta0n_rf=0
parameters dpeta0n_rf= - 1.5e-16 * 0.5 * (a1n_rf * fac_n_rf - sqrt(a1n_rf * fac_n_rf
+ * a1n_rf * fac_n_rf + 1e-8))
parameters dnfactorn_rf=a1n_rf * fac_n_rf * 0
parameters dlnfactorn_rf=a1n_rf * fac_n_rf * 5e-8
parameters dwnfactorn_rf=a1n_rf * fac_n_rf * 0
parameters dpnfactorn_rf=a1n_rf * fac_n_rf * 0.0e-15
parameters dvoffn_rf= - a1n_rf * fac_n_rf * 0.003
parameters dlvoffn_rf= - a1n_rf * fac_n_rf * 1.0e-9
parameters dwvoffn_rf= - a1n_rf * fac_n_rf * 0.7e-9
parameters dpvoffn_rf= - a1n_rf * fac_n_rf * 1.0e-15
parameters du0p_rf=a1p_rf * fac_p_rf * ( - 0.007e-2)
parameters dlu0p_rf=a1p_rf * fac_p_rf * ( - 0.1e-9)
parameters dwu0p_rf=a1p_rf * fac_p_rf * ( - 0.025e-9)
parameters dpu0p_rf=a1p_rf * fac_p_rf * ( - 0.0e-16)
parameters dvthp_rf=a1p_rf * fac_p_rf * ( - 0.030)
parameters dlvthp_rf=a1p_rf * fac_p_rf * ( - 5.00e-9)
parameters dwvthp_rf=a1p_rf * fac_p_rf * ( - 1.5e-9)
parameters dpvthp_rf=a1p_rf * fac_p_rf * ( - 1.5e-15)
parameters toxp_rf=4.08e-09 + a4np_rf * fac_p_rf * 1.33e-10 * 0.5
parameters dxlp_rf=a2np_rf * fac_p_rf * 1.33e-8 * 0.5
parameters dxwp_rf=a3np_rf * fac_p_rf * 2.2e-8 * 0.5
parameters drdswp_rf=0
parameters dk2p_rf=a1p_rf * fac_p_rf * 0.007
parameters dlk2p_rf=a1p_rf * fac_p_rf * 0.15e-8
parameters dvsatp_rf= - a1p_rf * fac_p_rf * 0.00e4
parameters dwvsatp_rf= - a1p_rf * fac_p_rf * 0.0e-3
parameters deta0p_rf=0
parameters dleta0p_rf= - 6e-10 * 0.5 * (a1p_rf * fac_p_rf - sqrt(a1p_rf * fac_p_rf
+ * a1p_rf * fac_p_rf + 1e-8))
parameters dweta0p_rf=0
parameters dpeta0p_rf= - 0.6e-16 * 0.5 * (a1p_rf * fac_p_rf - sqrt(a1p_rf * fac_p_rf
+ * a1p_rf * fac_p_rf + 1e-8))
parameters dnfactorp_rf=a1p_rf * fac_p_rf * 0
parameters dlnfactorp_rf= - a1p_rf * fac_p_rf * 0.5e-8
parameters dwnfactorp_rf= - a1p_rf * fac_p_rf * 0
parameters dpnfactorp_rf=0
parameters dvoffp_rf= - a1p_rf * fac_p_rf * 0.000
parameters dlvoffp_rf= - a1p_rf * fac_p_rf * 0.2e-8
parameters dwvoffp_rf= - a1p_rf * fac_p_rf * 0.0e-8
parameters dpvoffp_rf= - a1p_rf * fac_p_rf * 0.0e-15
parameters cjn_rf=0.001000266
parameters cjswn_rf=2.040547e-10
parameters cjswgn_rf=3.340547e-10
parameters cgon_rf=3.665e-10
parameters hdifn_rf=2e-07
parameters rshn_rf=6.8
parameters dk1n_rf=0
parameters drdswn_rf=0
parameters cjp_rf=0.001121
parameters cjswp_rf=2.481e-10
parameters cjswgp_rf=4.221e-10
parameters cgop_rf=3.28e-10
parameters hdifp_rf=2e-07
parameters rshp_rf=7.2

statistics {
    mismatch {
        vary vthnmis_rf dist=gauss std=1/1
        vary dlnmis_rf dist=gauss std=1/1
        vary dwnmis_rf dist=gauss std=1/1
        vary toxnmis_rf dist=gauss std=1/1
        vary vthpmis_rf dist=gauss std=1/1
        vary dlpmis_rf dist=gauss std=1/1
        vary dwpmis_rf dist=gauss std=1/1
        vary toxpmis_rf dist=gauss std=1/1
        }
    }
include "rf018.scs" section=rf_mos
endsection tt_rfmos

//  ****************************  LIBRARY OF FNFP CORNER CASE  ******************************
section ff_rfmos
parameters a1n_rf=-1
parameters a1p_rf=-1
parameters a2np_rf=-1
parameters a3np_rf=1
parameters a4np_rf=-1
parameters vthnmis_rf=0
parameters dlnmis_rf=0
parameters dwnmis_rf=0
parameters toxnmis_rf=0
parameters vthpmis_rf=0
parameters dlpmis_rf=0
parameters dwpmis_rf=0
parameters toxpmis_rf=0
parameters fac_n_rf=0.3766 * 2.4
parameters fac_p_rf=0.3766 * 2.1
parameters du0n_rf=a1n_rf * fac_n_rf * ( - 0.2e-2)
parameters dlu0n_rf=a1n_rf * fac_n_rf * ( - 0.5e-9)
parameters dwu0n_rf=a1n_rf * fac_n_rf * ( - 0.00e-9)
parameters dpu0n_rf=a1n_rf * fac_n_rf * ( - 0.0e-16)
parameters dvthn_rf=a1n_rf * fac_n_rf * 0.0205
parameters dlvthn_rf=a1n_rf * fac_n_rf * 2.9e-9
parameters dwvthn_rf=a1n_rf * fac_n_rf * 6.60e-9
parameters dpvthn_rf=a1n_rf * fac_n_rf * 3.0e-15
parameters toxn_rf=4.08e-09 + a4np_rf * fac_n_rf * 1.33e-10 * 0.5
parameters dxln_rf=a2np_rf * fac_n_rf * 1.33e-8 * 0.5
parameters dxwn_rf=a3np_rf * fac_n_rf * 2.2e-8 * 0.5
parameters dk2n_rf=a1n_rf * fac_n_rf * 0.008
parameters dlk2n_rf=a1n_rf * fac_n_rf * 0.4e-8
parameters dvsatn_rf= - a1n_rf * fac_n_rf * 0.4e4
parameters dwvsatn_rf= - a1n_rf * fac_n_rf * 0.0e-3
parameters deta0n_rf=0.0 * a1n_rf * fac_n_rf
parameters dleta0n_rf= - 0.35e-9 * 0.5 * (a1n_rf * fac_n_rf - sqrt(a1n_rf * fac_n_rf
+ * a1n_rf * fac_n_rf + 1e-8))
parameters dweta0n_rf=0
parameters dpeta0n_rf= - 1.5e-16 * 0.5 * (a1n_rf * fac_n_rf - sqrt(a1n_rf * fac_n_rf
+ * a1n_rf * fac_n_rf + 1e-8))
parameters dnfactorn_rf=a1n_rf * fac_n_rf * 0
parameters dlnfactorn_rf=a1n_rf * fac_n_rf * 5e-8
parameters dwnfactorn_rf=a1n_rf * fac_n_rf * 0
parameters dpnfactorn_rf=a1n_rf * fac_n_rf * 0.0e-15
parameters dvoffn_rf= - a1n_rf * fac_n_rf * 0.003
parameters dlvoffn_rf= - a1n_rf * fac_n_rf * 1.0e-9
parameters dwvoffn_rf= - a1n_rf * fac_n_rf * 0.7e-9
parameters dpvoffn_rf= - a1n_rf * fac_n_rf * 1.0e-15
parameters du0p_rf=a1p_rf * fac_p_rf * ( - 0.007e-2)
parameters dlu0p_rf=a1p_rf * fac_p_rf * ( - 0.1e-9)
parameters dwu0p_rf=a1p_rf * fac_p_rf * ( - 0.025e-9)
parameters dpu0p_rf=a1p_rf * fac_p_rf * ( - 0.0e-16)
parameters dvthp_rf=a1p_rf * fac_p_rf * ( - 0.030)
parameters dlvthp_rf=a1p_rf * fac_p_rf * ( - 5.00e-9)
parameters dwvthp_rf=a1p_rf * fac_p_rf * ( - 1.5e-9)
parameters dpvthp_rf=a1p_rf * fac_p_rf * ( - 1.5e-15)
parameters toxp_rf=4.08e-09 + a4np_rf * fac_p_rf * 1.33e-10 * 0.5
parameters dxlp_rf=a2np_rf * fac_p_rf * 1.33e-8 * 0.5
parameters dxwp_rf=a3np_rf * fac_p_rf * 2.2e-8 * 0.5
parameters drdswp_rf=0
parameters dk2p_rf=a1p_rf * fac_p_rf * 0.007
parameters dlk2p_rf=a1p_rf * fac_p_rf * 0.15e-8
parameters dvsatp_rf= - a1p_rf * fac_p_rf * 0.00e4
parameters dwvsatp_rf= - a1p_rf * fac_p_rf * 0.0e-3
parameters deta0p_rf=0
parameters dleta0p_rf= - 6e-10 * 0.5 * (a1p_rf * fac_p_rf - sqrt(a1p_rf * fac_p_rf
+ * a1p_rf * fac_p_rf + 1e-8))
parameters dweta0p_rf=0
parameters dpeta0p_rf= - 0.6e-16 * 0.5 * (a1p_rf * fac_p_rf - sqrt(a1p_rf * fac_p_rf
+ * a1p_rf * fac_p_rf + 1e-8))
parameters dnfactorp_rf=a1p_rf * fac_p_rf * 0
parameters dlnfactorp_rf= - a1p_rf * fac_p_rf * 0.5e-8
parameters dwnfactorp_rf= - a1p_rf * fac_p_rf * 0
parameters dpnfactorp_rf=0
parameters dvoffp_rf= - a1p_rf * fac_p_rf * 0.000
parameters dlvoffp_rf= - a1p_rf * fac_p_rf * 0.2e-8
parameters dwvoffp_rf= - a1p_rf * fac_p_rf * 0.0e-8
parameters dpvoffp_rf= - a1p_rf * fac_p_rf * 0.0e-15
parameters cjn_rf=0.0009502527
parameters cjswn_rf=1.93852e-10
parameters cjswgn_rf=3.17352e-10
parameters cgon_rf=3.84825e-10
parameters hdifn_rf=2e-07
parameters rshn_rf=6.8
parameters dk1n_rf=0
parameters drdswn_rf=0
parameters cjp_rf=0.00106495
parameters cjswp_rf=2.35695e-10
parameters cjswgp_rf=4.00995e-10
parameters cgop_rf=3.444e-10
parameters hdifp_rf=2e-07
parameters rshp_rf=7.2

statistics {
    mismatch {
        vary vthnmis_rf dist=gauss std=1/1
        vary dlnmis_rf dist=gauss std=1/1
        vary dwnmis_rf dist=gauss std=1/1
        vary toxnmis_rf dist=gauss std=1/1
        vary vthpmis_rf dist=gauss std=1/1
        vary dlpmis_rf dist=gauss std=1/1
        vary dwpmis_rf dist=gauss std=1/1
        vary toxpmis_rf dist=gauss std=1/1
        }
    }

include "rf018.scs" section=rf_mos
endsection ff_rfmos

//  ****************************  LIBRARY OF SNSP CORNER CASE  ******************************
section ss_rfmos
parameters a1n_rf=1
parameters a1p_rf=1
parameters a2np_rf=1
parameters a3np_rf=-1
parameters a4np_rf=1
parameters vthnmis_rf=0
parameters dlnmis_rf=0
parameters dwnmis_rf=0
parameters toxnmis_rf=0
parameters vthpmis_rf=0
parameters dlpmis_rf=0
parameters dwpmis_rf=0
parameters toxpmis_rf=0
parameters fac_n_rf=0.3766 * 2.4
parameters fac_p_rf=0.3766 * 2.1
parameters du0n_rf=a1n_rf * fac_n_rf * ( - 0.2e-2)
parameters dlu0n_rf=a1n_rf * fac_n_rf * ( - 0.5e-9)
parameters dwu0n_rf=a1n_rf * fac_n_rf * ( - 0.00e-9)
parameters dpu0n_rf=a1n_rf * fac_n_rf * ( - 0.0e-16)
parameters dvthn_rf=a1n_rf * fac_n_rf * 0.0205
parameters dlvthn_rf=a1n_rf * fac_n_rf * 2.9e-9
parameters dwvthn_rf=a1n_rf * fac_n_rf * 6.60e-9
parameters dpvthn_rf=a1n_rf * fac_n_rf * 3.0e-15
parameters toxn_rf=4.08e-09 + a4np_rf * fac_n_rf * 1.33e-10 * 0.5
parameters dxln_rf=a2np_rf * fac_n_rf * 1.33e-8 * 0.5
parameters dxwn_rf=a3np_rf * fac_n_rf * 2.2e-8 * 0.5
parameters dk2n_rf=a1n_rf * fac_n_rf * 0.008
parameters dlk2n_rf=a1n_rf * fac_n_rf * 0.4e-8
parameters dvsatn_rf= - a1n_rf * fac_n_rf * 0.4e4
parameters dwvsatn_rf= - a1n_rf * fac_n_rf * 0.0e-3
parameters deta0n_rf=0.0 * a1n_rf * fac_n_rf
parameters dleta0n_rf= - 0.35e-9 * 0.5 * (a1n_rf * fac_n_rf - sqrt(a1n_rf * fac_n_rf
+ * a1n_rf * fac_n_rf + 1e-8))
parameters dweta0n_rf=0
parameters dpeta0n_rf= - 1.5e-16 * 0.5 * (a1n_rf * fac_n_rf - sqrt(a1n_rf * fac_n_rf
+ * a1n_rf * fac_n_rf + 1e-8))
parameters dnfactorn_rf=a1n_rf * fac_n_rf * 0
parameters dlnfactorn_rf=a1n_rf * fac_n_rf * 5e-8
parameters dwnfactorn_rf=a1n_rf * fac_n_rf * 0
parameters dpnfactorn_rf=a1n_rf * fac_n_rf * 0.0e-15
parameters dvoffn_rf= - a1n_rf * fac_n_rf * 0.003
parameters dlvoffn_rf= - a1n_rf * fac_n_rf * 1.0e-9
parameters dwvoffn_rf= - a1n_rf * fac_n_rf * 0.7e-9
parameters dpvoffn_rf= - a1n_rf * fac_n_rf * 1.0e-15
parameters du0p_rf=a1p_rf * fac_p_rf * ( - 0.007e-2)
parameters dlu0p_rf=a1p_rf * fac_p_rf * ( - 0.1e-9)
parameters dwu0p_rf=a1p_rf * fac_p_rf * ( - 0.025e-9)
parameters dpu0p_rf=a1p_rf * fac_p_rf * ( - 0.0e-16)
parameters dvthp_rf=a1p_rf * fac_p_rf * ( - 0.030)
parameters dlvthp_rf=a1p_rf * fac_p_rf * ( - 5.00e-9)
parameters dwvthp_rf=a1p_rf * fac_p_rf * ( - 1.5e-9)
parameters dpvthp_rf=a1p_rf * fac_p_rf * ( - 1.5e-15)
parameters toxp_rf=4.08e-09 + a4np_rf * fac_p_rf * 1.33e-10 * 0.5
parameters dxlp_rf=a2np_rf * fac_p_rf * 1.33e-8 * 0.5
parameters dxwp_rf=a3np_rf * fac_p_rf * 2.2e-8 * 0.5
parameters drdswp_rf=0
parameters dk2p_rf=a1p_rf * fac_p_rf * 0.007
parameters dlk2p_rf=a1p_rf * fac_p_rf * 0.15e-8
parameters dvsatp_rf= - a1p_rf * fac_p_rf * 0.00e4
parameters dwvsatp_rf= - a1p_rf * fac_p_rf * 0.0e-3
parameters deta0p_rf=0
parameters dleta0p_rf= - 6e-10 * 0.5 * (a1p_rf * fac_p_rf - sqrt(a1p_rf * fac_p_rf
+ * a1p_rf * fac_p_rf + 1e-8))
parameters dweta0p_rf=0
parameters dpeta0p_rf= - 0.6e-16 * 0.5 * (a1p_rf * fac_p_rf - sqrt(a1p_rf * fac_p_rf
+ * a1p_rf * fac_p_rf + 1e-8))
parameters dnfactorp_rf=a1p_rf * fac_p_rf * 0
parameters dlnfactorp_rf= - a1p_rf * fac_p_rf * 0.5e-8
parameters dwnfactorp_rf= - a1p_rf * fac_p_rf * 0
parameters dpnfactorp_rf=0
parameters dvoffp_rf= - a1p_rf * fac_p_rf * 0.000
parameters dlvoffp_rf= - a1p_rf * fac_p_rf * 0.2e-8
parameters dwvoffp_rf= - a1p_rf * fac_p_rf * 0.0e-8
parameters dpvoffp_rf= - a1p_rf * fac_p_rf * 0.0e-15
parameters cjn_rf=0.001050279
parameters cjswn_rf=2.142574e-10
parameters cjswgn_rf=3.507574e-10
parameters cgon_rf=3.48175e-10
parameters hdifn_rf=2e-07
parameters rshn_rf=6.8
parameters dk1n_rf=0
parameters drdswn_rf=0
parameters cjp_rf=0.00117705
parameters cjswp_rf=2.60505e-10
parameters cjswgp_rf=4.43205e-10
parameters cgop_rf=3.116e-10
parameters hdifp_rf=2e-07
parameters rshp_rf=7.2

statistics {
    mismatch {
        vary vthnmis_rf dist=gauss std=1/1
        vary dlnmis_rf dist=gauss std=1/1
        vary dwnmis_rf dist=gauss std=1/1
        vary toxnmis_rf dist=gauss std=1/1
        vary vthpmis_rf dist=gauss std=1/1
        vary dlpmis_rf dist=gauss std=1/1
        vary dwpmis_rf dist=gauss std=1/1
        vary toxpmis_rf dist=gauss std=1/1
        }
    }
include "rf018.scs" section=rf_mos
endsection ss_rfmos

//  ****************************  LIBRARY OF SNFP CORNER CASE  ******************************
section sf_rfmos
parameters a1n_rf=1
parameters a1p_rf=-1
parameters a2np_rf=0
parameters a3np_rf=0
parameters a4np_rf=0
parameters vthnmis_rf=0
parameters dlnmis_rf=0
parameters dwnmis_rf=0
parameters toxnmis_rf=0
parameters vthpmis_rf=0
parameters dlpmis_rf=0
parameters dwpmis_rf=0
parameters toxpmis_rf=0
parameters fac_n_rf=0.3766 * 2.4
parameters fac_p_rf=0.3766 * 2.1
parameters du0n_rf=a1n_rf * fac_n_rf * ( - 0.2e-2)
parameters dlu0n_rf=a1n_rf * fac_n_rf * ( - 0.5e-9)
parameters dwu0n_rf=a1n_rf * fac_n_rf * ( - 0.00e-9)
parameters dpu0n_rf=a1n_rf * fac_n_rf * ( - 0.0e-16)
parameters dvthn_rf=a1n_rf * fac_n_rf * 0.0205
parameters dlvthn_rf=a1n_rf * fac_n_rf * 2.9e-9
parameters dwvthn_rf=a1n_rf * fac_n_rf * 6.60e-9
parameters dpvthn_rf=a1n_rf * fac_n_rf * 3.0e-15
parameters toxn_rf=4.08e-09 + a4np_rf * fac_n_rf * 1.33e-10 * 0.5
parameters dxln_rf=a2np_rf * fac_n_rf * 1.33e-8 * 0.5
parameters dxwn_rf=a3np_rf * fac_n_rf * 2.2e-8 * 0.5
parameters dk2n_rf=a1n_rf * fac_n_rf * 0.008
parameters dlk2n_rf=a1n_rf * fac_n_rf * 0.4e-8
parameters dvsatn_rf= - a1n_rf * fac_n_rf * 0.4e4
parameters dwvsatn_rf= - a1n_rf * fac_n_rf * 0.0e-3
parameters deta0n_rf=0.0 * a1n_rf * fac_n_rf
parameters dleta0n_rf= - 0.35e-9 * 0.5 * (a1n_rf * fac_n_rf - sqrt(a1n_rf * fac_n_rf
+ * a1n_rf * fac_n_rf + 1e-8))
parameters dweta0n_rf=0
parameters dpeta0n_rf= - 1.5e-16 * 0.5 * (a1n_rf * fac_n_rf - sqrt(a1n_rf * fac_n_rf
+ * a1n_rf * fac_n_rf + 1e-8))
parameters dnfactorn_rf=a1n_rf * fac_n_rf * 0
parameters dlnfactorn_rf=a1n_rf * fac_n_rf * 5e-8
parameters dwnfactorn_rf=a1n_rf * fac_n_rf * 0
parameters dpnfactorn_rf=a1n_rf * fac_n_rf * 0.0e-15
parameters dvoffn_rf= - a1n_rf * fac_n_rf * 0.003
parameters dlvoffn_rf= - a1n_rf * fac_n_rf * 1.0e-9
parameters dwvoffn_rf= - a1n_rf * fac_n_rf * 0.7e-9
parameters dpvoffn_rf= - a1n_rf * fac_n_rf * 1.0e-15
parameters du0p_rf=a1p_rf * fac_p_rf * ( - 0.007e-2)
parameters dlu0p_rf=a1p_rf * fac_p_rf * ( - 0.1e-9)
parameters dwu0p_rf=a1p_rf * fac_p_rf * ( - 0.025e-9)
parameters dpu0p_rf=a1p_rf * fac_p_rf * ( - 0.0e-16)
parameters dvthp_rf=a1p_rf * fac_p_rf * ( - 0.030)
parameters dlvthp_rf=a1p_rf * fac_p_rf * ( - 5.00e-9)
parameters dwvthp_rf=a1p_rf * fac_p_rf * ( - 1.5e-9)
parameters dpvthp_rf=a1p_rf * fac_p_rf * ( - 1.5e-15)
parameters toxp_rf=4.08e-09 + a4np_rf * fac_p_rf * 1.33e-10 * 0.5
parameters dxlp_rf=a2np_rf * fac_p_rf * 1.33e-8 * 0.5
parameters dxwp_rf=a3np_rf * fac_p_rf * 2.2e-8 * 0.5
parameters drdswp_rf=0
parameters dk2p_rf=a1p_rf * fac_p_rf * 0.007
parameters dlk2p_rf=a1p_rf * fac_p_rf * 0.15e-8
parameters dvsatp_rf= - a1p_rf * fac_p_rf * 0.00e4
parameters dwvsatp_rf= - a1p_rf * fac_p_rf * 0.0e-3
parameters deta0p_rf=0
parameters dleta0p_rf= - 6e-10 * 0.5 * (a1p_rf * fac_p_rf - sqrt(a1p_rf * fac_p_rf
+ * a1p_rf * fac_p_rf + 1e-8))
parameters dweta0p_rf=0
parameters dpeta0p_rf= - 0.6e-16 * 0.5 * (a1p_rf * fac_p_rf - sqrt(a1p_rf * fac_p_rf
+ * a1p_rf * fac_p_rf + 1e-8))
parameters dnfactorp_rf=a1p_rf * fac_p_rf * 0
parameters dlnfactorp_rf= - a1p_rf * fac_p_rf * 0.5e-8
parameters dwnfactorp_rf= - a1p_rf * fac_p_rf * 0
parameters dpnfactorp_rf=0
parameters dvoffp_rf= - a1p_rf * fac_p_rf * 0.000
parameters dlvoffp_rf= - a1p_rf * fac_p_rf * 0.2e-8
parameters dwvoffp_rf= - a1p_rf * fac_p_rf * 0.0e-8
parameters dpvoffp_rf= - a1p_rf * fac_p_rf * 0.0e-15
parameters cjn_rf=0.001050279
parameters cjswn_rf=2.142574e-10
parameters cjswgn_rf=3.507574e-10
parameters cgon_rf=3.665e-10
parameters hdifn_rf=2e-07
parameters rshn_rf=6.8
parameters dk1n_rf=0
parameters drdswn_rf=0
parameters cjp_rf=0.00106495
parameters cjswp_rf=2.35695e-10
parameters cjswgp_rf=4.00995e-10
parameters cgop_rf=3.28e-10
parameters hdifp_rf=2e-07
parameters rshp_rf=7.2

statistics {
    mismatch {
        vary vthnmis_rf dist=gauss std=1/1
        vary dlnmis_rf dist=gauss std=1/1
        vary dwnmis_rf dist=gauss std=1/1
        vary toxnmis_rf dist=gauss std=1/1
        vary vthpmis_rf dist=gauss std=1/1
        vary dlpmis_rf dist=gauss std=1/1
        vary dwpmis_rf dist=gauss std=1/1
        vary toxpmis_rf dist=gauss std=1/1
        }
    }

include "rf018.scs" section=rf_mos
endsection sf_rfmos

//  ****************************  LIBRARY OF FNSP CORNER CASE  ******************************
section fs_rfmos
parameters a1n_rf=-1
parameters a1p_rf=1
parameters a2np_rf=0
parameters a3np_rf=0
parameters a4np_rf=0
parameters vthnmis_rf=0
parameters dlnmis_rf=0
parameters dwnmis_rf=0
parameters toxnmis_rf=0
parameters vthpmis_rf=0
parameters dlpmis_rf=0
parameters dwpmis_rf=0
parameters toxpmis_rf=0
parameters fac_n_rf=0.3766 * 2.4
parameters fac_p_rf=0.3766 * 2.1
parameters du0n_rf=a1n_rf * fac_n_rf * ( - 0.2e-2)
parameters dlu0n_rf=a1n_rf * fac_n_rf * ( - 0.5e-9)
parameters dwu0n_rf=a1n_rf * fac_n_rf * ( - 0.00e-9)
parameters dpu0n_rf=a1n_rf * fac_n_rf * ( - 0.0e-16)
parameters dvthn_rf=a1n_rf * fac_n_rf * 0.0205
parameters dlvthn_rf=a1n_rf * fac_n_rf * 2.9e-9
parameters dwvthn_rf=a1n_rf * fac_n_rf * 6.60e-9
parameters dpvthn_rf=a1n_rf * fac_n_rf * 3.0e-15
parameters toxn_rf=4.08e-09 + a4np_rf * fac_n_rf * 1.33e-10 * 0.5
parameters dxln_rf=a2np_rf * fac_n_rf * 1.33e-8 * 0.5
parameters dxwn_rf=a3np_rf * fac_n_rf * 2.2e-8 * 0.5
parameters dk2n_rf=a1n_rf * fac_n_rf * 0.008
parameters dlk2n_rf=a1n_rf * fac_n_rf * 0.4e-8
parameters dvsatn_rf= - a1n_rf * fac_n_rf * 0.4e4
parameters dwvsatn_rf= - a1n_rf * fac_n_rf * 0.0e-3
parameters deta0n_rf=0.0 * a1n_rf * fac_n_rf
parameters dleta0n_rf= - 0.35e-9 * 0.5 * (a1n_rf * fac_n_rf - sqrt(a1n_rf * fac_n_rf
+ * a1n_rf * fac_n_rf + 1e-8))
parameters dweta0n_rf=0
parameters dpeta0n_rf= - 1.5e-16 * 0.5 * (a1n_rf * fac_n_rf - sqrt(a1n_rf * fac_n_rf
+ * a1n_rf * fac_n_rf + 1e-8))
parameters dnfactorn_rf=a1n_rf * fac_n_rf * 0
parameters dlnfactorn_rf=a1n_rf * fac_n_rf * 5e-8
parameters dwnfactorn_rf=a1n_rf * fac_n_rf * 0
parameters dpnfactorn_rf=a1n_rf * fac_n_rf * 0.0e-15
parameters dvoffn_rf= - a1n_rf * fac_n_rf * 0.003
parameters dlvoffn_rf= - a1n_rf * fac_n_rf * 1.0e-9
parameters dwvoffn_rf= - a1n_rf * fac_n_rf * 0.7e-9
parameters dpvoffn_rf= - a1n_rf * fac_n_rf * 1.0e-15
parameters du0p_rf=a1p_rf * fac_p_rf * ( - 0.007e-2)
parameters dlu0p_rf=a1p_rf * fac_p_rf * ( - 0.1e-9)
parameters dwu0p_rf=a1p_rf * fac_p_rf * ( - 0.025e-9)
parameters dpu0p_rf=a1p_rf * fac_p_rf * ( - 0.0e-16)
parameters dvthp_rf=a1p_rf * fac_p_rf * ( - 0.030)
parameters dlvthp_rf=a1p_rf * fac_p_rf * ( - 5.00e-9)
parameters dwvthp_rf=a1p_rf * fac_p_rf * ( - 1.5e-9)
parameters dpvthp_rf=a1p_rf * fac_p_rf * ( - 1.5e-15)
parameters toxp_rf=4.08e-09 + a4np_rf * fac_p_rf * 1.33e-10 * 0.5
parameters dxlp_rf=a2np_rf * fac_p_rf * 1.33e-8 * 0.5
parameters dxwp_rf=a3np_rf * fac_p_rf * 2.2e-8 * 0.5
parameters drdswp_rf=0
parameters dk2p_rf=a1p_rf * fac_p_rf * 0.007
parameters dlk2p_rf=a1p_rf * fac_p_rf * 0.15e-8
parameters dvsatp_rf= - a1p_rf * fac_p_rf * 0.00e4
parameters dwvsatp_rf= - a1p_rf * fac_p_rf * 0.0e-3
parameters deta0p_rf=0
parameters dleta0p_rf= - 6e-10 * 0.5 * (a1p_rf * fac_p_rf - sqrt(a1p_rf * fac_p_rf
+ * a1p_rf * fac_p_rf + 1e-8))
parameters dweta0p_rf=0
parameters dpeta0p_rf= - 0.6e-16 * 0.5 * (a1p_rf * fac_p_rf - sqrt(a1p_rf * fac_p_rf
+ * a1p_rf * fac_p_rf + 1e-8))
parameters dnfactorp_rf=a1p_rf * fac_p_rf * 0
parameters dlnfactorp_rf= - a1p_rf * fac_p_rf * 0.5e-8
parameters dwnfactorp_rf= - a1p_rf * fac_p_rf * 0
parameters dpnfactorp_rf=0
parameters dvoffp_rf= - a1p_rf * fac_p_rf * 0.000
parameters dlvoffp_rf= - a1p_rf * fac_p_rf * 0.2e-8
parameters dwvoffp_rf= - a1p_rf * fac_p_rf * 0.0e-8
parameters dpvoffp_rf= - a1p_rf * fac_p_rf * 0.0e-15
parameters cjn_rf=0.0009502527
parameters cjswn_rf=1.93852e-10
parameters cjswgn_rf=3.17352e-10
parameters cgon_rf=3.665e-10
parameters hdifn_rf=2e-07
parameters rshn_rf=6.8
parameters dk1n_rf=0
parameters drdswn_rf=0
parameters cjp_rf=0.00117705
parameters cjswp_rf=2.60505e-10
parameters cjswgp_rf=4.43205e-10
parameters cgop_rf=3.28e-10
parameters hdifp_rf=2e-07
parameters rshp_rf=7.2

statistics {
    mismatch {
        vary vthnmis_rf dist=gauss std=1/1
        vary dlnmis_rf dist=gauss std=1/1
        vary dwnmis_rf dist=gauss std=1/1
        vary toxnmis_rf dist=gauss std=1/1
        vary vthpmis_rf dist=gauss std=1/1
        vary dlpmis_rf dist=gauss std=1/1
        vary dwpmis_rf dist=gauss std=1/1
        vary toxpmis_rf dist=gauss std=1/1
        }
    }

include "rf018.scs" section=rf_mos
endsection fs_rfmos

//  ****************************    LIBRARY OF statistical model    ******************************

section mc_rfmos
parameters vthnmis_rf=0
parameters dlnmis_rf=0
parameters dwnmis_rf=0
parameters toxnmis_rf=0
parameters vthpmis_rf=0
parameters dlpmis_rf=0
parameters dwpmis_rf=0
parameters toxpmis_rf=0
parameters par1_rf=0
parameters par2_rf=0
parameters par3_rf=0
parameters par4_rf=0
parameters par5_rf=0
parameters a1n_rf=par1_rf
parameters a1p_rf=par2_rf
parameters a2np_rf=par3_rf
parameters a3np_rf=par4_rf
parameters a4np_rf=par5_rf
parameters fac_n_rf=1.00 * 2.4
parameters fac_p_rf=1.00 * 2.1
parameters du0n_rf=a1n_rf * fac_n_rf * ( - 0.06e-2) + a4np_rf * fac_n_rf * ( - 0.02e-2)
parameters dlu0n_rf=a1n_rf * fac_n_rf * ( - 0.22e-9)
parameters dwu0n_rf=a1n_rf * fac_n_rf * ( - 0.00e-9)
parameters dpu0n_rf=a1n_rf * fac_n_rf * ( - 1.0e-16)
parameters dvthn_rf=a1n_rf * fac_n_rf * 0.0095
parameters dlvthn_rf=a1n_rf * fac_n_rf * 1.05e-9
parameters dwvthn_rf=a1n_rf * fac_n_rf * 2.25e-9
parameters dpvthn_rf=a1n_rf * fac_n_rf * 1.0e-15
parameters toxn_rf=4.08e-09 + a4np_rf * fac_n_rf * 0.5e-10
parameters dxln_rf=a2np_rf * fac_n_rf * 0.8e-8
parameters dxwn_rf=a3np_rf * fac_n_rf * 1.20e-8
parameters dk2n_rf=a1n_rf * fac_n_rf * 0.002 + a4np_rf * fac_n_rf * 0.001
parameters dlk2n_rf=a1n_rf * fac_n_rf * 0.12e-8 + a4np_rf * fac_n_rf * 0.10e-8
parameters dvsatn_rf= - a1n_rf * fac_n_rf * 0.27e4
parameters dwvsatn_rf= - a1n_rf * fac_n_rf * 0.3e-3
parameters deta0n_rf=0.0 * a1n_rf * fac_n_rf
parameters dleta0n_rf= - 0.08e-9 * 0.5 * (a1n_rf * fac_n_rf - sqrt(a1n_rf * fac_n_rf
+ * a1n_rf * fac_n_rf + 1e-8)) - 0.8e-10 * 0.5 * (a2np_rf * fac_n_rf - sqrt(a2np_rf
+ * fac_n_rf * a2np_rf * fac_n_rf + 1e-8))
parameters dweta0n_rf=0
parameters dpeta0n_rf= - 0.0e-16 * 0.5 * (a1n_rf * fac_n_rf - sqrt(a1n_rf * fac_n_rf
+ * a1n_rf * fac_n_rf + 1e-8)) - 1.0e-16 * 0.5 * (a2np_rf * fac_n_rf - sqrt(a2np_rf
+ * fac_n_rf * a2np_rf * fac_n_rf + 1e-8)) + 1.0e-16 * 0.5 * (a3np_rf * fac_n_rf
+ + sqrt(a3np_rf * fac_n_rf * a3np_rf * fac_n_rf + 1e-8))
parameters dnfactorn_rf=a1n_rf * fac_n_rf * 0
parameters dlnfactorn_rf=a1n_rf * fac_n_rf * 1.5e-8 + a2np_rf * fac_n_rf * 1.1e-8
parameters dwnfactorn_rf=a1n_rf * fac_n_rf * 0
parameters dpnfactorn_rf=a1n_rf * fac_n_rf * 0.0e-15 + a2np_rf * fac_n_rf * 0.2e-15
+ - a3np_rf * fac_n_rf * 0.2e-15
parameters dvoffn_rf= - a1n_rf * fac_n_rf * 0.003
parameters dlvoffn_rf= - a1n_rf * fac_n_rf * 0.000
parameters dwvoffn_rf= - a1n_rf * fac_n_rf * 0.000
parameters dpvoffn_rf= - a1n_rf * fac_n_rf * 0.0e-15 - a2np_rf * fac_n_rf * 0.43e-15
+ + a3np_rf * fac_n_rf * 0.43e-15
parameters du0p_rf=a1p_rf * fac_p_rf * ( - 0.001e-2) + a4np_rf * fac_p_rf * ( -
+ 0.001e-2)
parameters dlu0p_rf=a1p_rf * fac_p_rf * ( - 0.05e-9)
parameters dwu0p_rf=a1p_rf * fac_p_rf * (0e-9)
parameters dpu0p_rf=a1p_rf * fac_p_rf * ( - 0.05e-16)
parameters dvthp_rf=a1p_rf * fac_p_rf * ( - 0.0125)
parameters dlvthp_rf=a1p_rf * fac_p_rf * ( - 0.8e-9)
parameters dwvthp_rf=a1p_rf * fac_p_rf * ( - 1.6e-9)
parameters dpvthp_rf=a1p_rf * fac_p_rf * ( - 0.2e-15)
parameters toxp_rf=4.08e-09 + a4np_rf * fac_p_rf * 0.5e-10
parameters dxlp_rf=a2np_rf * fac_p_rf * 0.8e-8
parameters dxwp_rf=a3np_rf * fac_p_rf * 1.20e-8
parameters drdswp_rf=0
parameters dk2p_rf=a1p_rf * fac_p_rf * 0.002 + a4np_rf * fac_p_rf * 0.0001
parameters dlk2p_rf=a1p_rf * fac_p_rf * 0.08e-8 + a4np_rf * fac_p_rf * 0.04e-8
parameters dvsatp_rf= - a1p_rf * fac_p_rf * 1.00e4
parameters dwvsatp_rf= - a1p_rf * fac_p_rf * 0.3e-3
parameters deta0p_rf=0
parameters dleta0p_rf= - 0e-10 * 0.5 * (a1p_rf * fac_p_rf - sqrt(a1p_rf * fac_p_rf
+ * a1p_rf * fac_p_rf + 1e-8)) - 1.6e-10 * 0.5 * (a2np_rf * fac_p_rf - sqrt(a2np_rf
+ * fac_p_rf * a2np_rf * fac_p_rf + 1e-8))
parameters dweta0p_rf=0
parameters dpeta0p_rf= - 0.1e-16 * 0.5 * (a1p_rf * fac_p_rf - sqrt(a1p_rf * fac_p_rf
+ * a1p_rf * fac_p_rf + 1e-8)) - 0.5e-16 * 0.5 * (a2np_rf * fac_p_rf - sqrt(a2np_rf
+ * fac_p_rf * a2np_rf * fac_p_rf + 1e-8)) + 0.5e-16 * 0.5 * (a3np_rf * fac_p_rf
+ + sqrt(a3np_rf * fac_p_rf * a3np_rf * fac_p_rf + 1e-8))
parameters dnfactorp_rf=a1p_rf * fac_p_rf * 0
parameters dlnfactorp_rf= - a1p_rf * fac_p_rf * 0.5e-8 + a2np_rf * fac_p_rf * 1.5e-8
parameters dwnfactorp_rf= - a1p_rf * fac_p_rf * 0
parameters dpnfactorp_rf=0
parameters dvoffp_rf= - a1p_rf * fac_p_rf * 0.000
parameters dlvoffp_rf=a1p_rf * fac_p_rf * 0.2e-8
parameters dwvoffp_rf= - a1p_rf * fac_p_rf * 0.2e-8
parameters dpvoffp_rf=a1p_rf * fac_p_rf * 0.9e-15 - a2np_rf * fac_p_rf * 0.1e-15
+ + a3np_rf * fac_p_rf * 0.1e-15
parameters cjn_rf=0.001000266 * (1 + 0.05 * a1n_rf)
parameters cjswn_rf=2.040547e-10 * (1 + 0.05 * a1n_rf)
parameters cjswgn_rf=3.340547e-10 * (1 + 0.05 * a1n_rf)
parameters cgon_rf=3.665e-10 * (1 - 0.05 * a4np_rf)
parameters hdifn_rf=2e-07
parameters rshn_rf=6.8
parameters dk1n_rf=0
parameters drdswn_rf=0
parameters cjp_rf=0.001121 * (1 + 0.05 * a1p_rf)
parameters cjswp_rf=2.481e-10 * (1 + 0.05 * a1p_rf)
parameters cjswgp_rf=4.221e-10 * (1 + 0.05 * a1p_rf)
parameters cgop_rf=3.28e-10 * (1 - 0.05 * a4np_rf)
parameters hdifp_rf=2e-07
parameters rshp_rf=7.2

statistics {
    process {
        vary par1_rf dist=gauss std=1/6
        vary par2_rf dist=gauss std=1/6
        vary par3_rf dist=gauss std=1/6
        vary par4_rf dist=gauss std=1/6
        vary par5_rf dist=gauss std=1/6
        }
    mismatch {
        vary vthnmis_rf dist=gauss std=1/1
        vary dlnmis_rf dist=gauss std=1/1
        vary dwnmis_rf dist=gauss std=1/1
        vary toxnmis_rf dist=gauss std=1/1
        vary vthpmis_rf dist=gauss std=1/1
        vary dlpmis_rf dist=gauss std=1/1
        vary dwpmis_rf dist=gauss std=1/1
        vary toxpmis_rf dist=gauss std=1/1
        }

    }

include "rf018.scs" section=rf_mos
endsection mc_rfmos

//  ******************************************************
//  *******    3.3V N/PMOS Corner Parameters   ***********
//  ******************************************************

section tt_rfmos33
parameters a1n_rf3=0
parameters a1p_rf3=0
parameters a2np_rf3=0
parameters a3np_rf3=0
parameters a4np_rf3=0
parameters vthnmis_rf3=0
parameters dlnmis_rf3=0
parameters dwnmis_rf3=0
parameters toxnmis_rf3=0
parameters vthpmis_rf3=0
parameters dlpmis_rf3=0
parameters dwpmis_rf3=0
parameters toxpmis_rf3=0
parameters fac_n_rf3=0.3766 * 3.6
parameters fac_p_rf3=0.3766 * 3.2
parameters du0n_rf3=a1n_rf3 * fac_n_rf3 * ( - 0.125e-2)
parameters dlu0n_rf3=a1n_rf3 * fac_n_rf3 * ( - 1.35e-9)
parameters dwu0n_rf3=a1n_rf3 * fac_n_rf3 * ( - 0.25e-9)
parameters dpu0n_rf3=a1n_rf3 * fac_n_rf3 * ( - 15e-16)
parameters dvthn_rf3=a1n_rf3 * fac_n_rf3 * 0.0155
parameters dlvthn_rf3=a1n_rf3 * fac_n_rf3 * 6.2e-9
parameters dwvthn_rf3=a1n_rf3 * fac_n_rf3 * 6.0e-9
parameters dpvthn_rf3=a1n_rf3 * fac_n_rf3 * 6.8e-15
parameters toxn_rf3=6.8e-09 + a4np_rf3 * fac_n_rf3 * 2.66e-10 * 0.5
parameters dxln_rf3=a2np_rf3 * fac_n_rf3 * 1.33e-8 * 0.5
parameters dxwn_rf3=a3np_rf3 * fac_n_rf3 * 2.2e-8 * 0.5
parameters dk2n_rf3=a1n_rf3 * fac_n_rf3 * 0.008
parameters dlk2n_rf3=a1n_rf3 * fac_n_rf3 * 0.8e-8
parameters dvsatn_rf3= - a1n_rf3 * fac_n_rf3 * 0.0e4
parameters dwvsatn_rf3= - a1n_rf3 * fac_n_rf3 * 0.0e-3
parameters deta0n_rf3=0.0 * a1n_rf3 * fac_n_rf3
parameters dleta0n_rf3= - 0.35e-9 * 0.5 * (a1n_rf3 * fac_n_rf3 - sqrt(a1n_rf3 *
+ fac_n_rf3 * a1n_rf3 * fac_n_rf3 + 1e-8))
parameters dweta0n_rf3=0
parameters dpeta0n_rf3= - 1.5e-16 * 0.5 * (a1n_rf3 * fac_n_rf3 - sqrt(a1n_rf3 *
+ fac_n_rf3 * a1n_rf3 * fac_n_rf3 + 1e-8))
parameters dnfactorn_rf3=a1n_rf3 * fac_n_rf3 * 0
parameters dlnfactorn_rf3=a1n_rf3 * fac_n_rf3 * 5e-8
parameters dwnfactorn_rf3=a1n_rf3 * fac_n_rf3 * 0
parameters dpnfactorn_rf3=a1n_rf3 * fac_n_rf3 * 0.0e-15
parameters dvoffn_rf3= - a1n_rf3 * fac_n_rf3 * 0.003
parameters dlvoffn_rf3= - a1n_rf3 * fac_n_rf3 * 1.0e-9
parameters dwvoffn_rf3= - a1n_rf3 * fac_n_rf3 * 0.7e-9
parameters dpvoffn_rf3= - a1n_rf3 * fac_n_rf3 * 1.0e-15
parameters du0p_rf3=a1p_rf3 * fac_p_rf3 * ( - 0.042e-2)
parameters dlu0p_rf3=a1p_rf3 * fac_p_rf3 * ( - 0.135e-9)
parameters dwu0p_rf3=a1p_rf3 * fac_p_rf3 * ( - 0.025e-9)
parameters dpu0p_rf3=a1p_rf3 * fac_p_rf3 * ( - 0.12e-16)
parameters dvthp_rf3=a1p_rf3 * fac_p_rf3 * ( - 0.0175)
parameters dlvthp_rf3=a1p_rf3 * fac_p_rf3 * ( - 1.47e-9)
parameters dwvthp_rf3=a1p_rf3 * fac_p_rf3 * ( - 1.3e-9)
parameters dpvthp_rf3=a1p_rf3 * fac_p_rf3 * ( - 2.3e-15)
parameters toxp_rf3=6.77e-09 + a4np_rf3 * fac_p_rf3 * 2.66e-10 * 0.5
parameters dxlp_rf3=a2np_rf3 * fac_p_rf3 * 1.33e-8 * 0.5
parameters dxwp_rf3=a3np_rf3 * fac_p_rf3 * 2.2e-8 * 0.5
parameters dk2p_rf3=a1p_rf3 * fac_p_rf3 * 0.01
parameters dlk2p_rf3=a1p_rf3 * fac_p_rf3 * 0.18e-8
parameters dvsatp_rf3= - a1p_rf3 * fac_p_rf3 * 0.00e4
parameters dwvsatp_rf3= - a1p_rf3 * fac_p_rf3 * 0.0e-3
parameters deta0p_rf3=0
parameters dleta0p_rf3= - 1e-10 * 0.5 * (a1p_rf3 * fac_p_rf3 - sqrt(a1p_rf3 * fac_p_rf3
+ * a1p_rf3 * fac_p_rf3 + 1e-8))
parameters dweta0p_rf3=0
parameters dpeta0p_rf3= - 1.2e-16 * 0.5 * (a1p_rf3 * fac_p_rf3 - sqrt(a1p_rf3 *
+ fac_p_rf3 * a1p_rf3 * fac_p_rf3 + 1e-8))
parameters dnfactorp_rf3=a1p_rf3 * fac_p_rf3 * 0
parameters dlnfactorp_rf3= - a1p_rf3 * fac_p_rf3 * 0.5e-8
parameters dwnfactorp_rf3= - a1p_rf3 * fac_p_rf3 * 0
parameters dpnfactorp_rf3=0
parameters dvoffp_rf3= - a1p_rf3 * fac_p_rf3 * 0.000
parameters dlvoffp_rf3= - a1p_rf3 * fac_p_rf3 * 0.0e-8
parameters dwvoffp_rf3= - a1p_rf3 * fac_p_rf3 * 0.0e-8
parameters dpvoffp_rf3= - a1p_rf3 * fac_p_rf3 * 0.0e-15
parameters cjn_rf3=0.0008964788
parameters cjswn_rf3=2.50664e-10
parameters cjswgn_rf3=3.00664e-10
parameters cgon_rf3=3.18e-10
parameters hdifn_rf3=2e-07
parameters rshn_rf3=6.8
parameters cjp_rf3=0.00103531
parameters cjswp_rf3=2.23115e-10
parameters cjswgp_rf3=2.345762e-10
parameters cgop_rf3=2.77e-10
parameters hdifp_rf3=2e-07
parameters rshp_rf3=7.2

statistics {
    mismatch {
        vary vthnmis_rf3 dist=gauss std=1/1
        vary dlnmis_rf3 dist=gauss std=1/1
        vary dwnmis_rf3 dist=gauss std=1/1
        vary toxnmis_rf3 dist=gauss std=1/1
        vary vthpmis_rf3 dist=gauss std=1/1
        vary dlpmis_rf3 dist=gauss std=1/1
        vary dwpmis_rf3 dist=gauss std=1/1
        vary toxpmis_rf3 dist=gauss std=1/1
        }
    }
include "rf018.scs" section=rf_mos33
endsection tt_rfmos33

//  ****************************  LIBRARY OF FNFP CORNER CASE  ******************************

section ff_rfmos33

parameters a1n_rf3=-1
parameters a1p_rf3=-1
parameters a2np_rf3=-1
parameters a3np_rf3=1
parameters a4np_rf3=-1
parameters vthnmis_rf3=0
parameters dlnmis_rf3=0
parameters dwnmis_rf3=0
parameters toxnmis_rf3=0
parameters vthpmis_rf3=0
parameters dlpmis_rf3=0
parameters dwpmis_rf3=0
parameters toxpmis_rf3=0
parameters fac_n_rf3=0.3766 * 3.6
parameters fac_p_rf3=0.3766 * 3.2
parameters du0n_rf3=a1n_rf3 * fac_n_rf3 * ( - 0.125e-2)
parameters dlu0n_rf3=a1n_rf3 * fac_n_rf3 * ( - 1.35e-9)
parameters dwu0n_rf3=a1n_rf3 * fac_n_rf3 * ( - 0.25e-9)
parameters dpu0n_rf3=a1n_rf3 * fac_n_rf3 * ( - 15e-16)
parameters dvthn_rf3=a1n_rf3 * fac_n_rf3 * 0.0155
parameters dlvthn_rf3=a1n_rf3 * fac_n_rf3 * 6.2e-9
parameters dwvthn_rf3=a1n_rf3 * fac_n_rf3 * 6.0e-9
parameters dpvthn_rf3=a1n_rf3 * fac_n_rf3 * 6.8e-15
parameters toxn_rf3=6.8e-09 + a4np_rf3 * fac_n_rf3 * 2.66e-10 * 0.5
parameters dxln_rf3=a2np_rf3 * fac_n_rf3 * 1.33e-8 * 0.5
parameters dxwn_rf3=a3np_rf3 * fac_n_rf3 * 2.2e-8 * 0.5
parameters dk2n_rf3=a1n_rf3 * fac_n_rf3 * 0.008
parameters dlk2n_rf3=a1n_rf3 * fac_n_rf3 * 0.8e-8
parameters dvsatn_rf3= - a1n_rf3 * fac_n_rf3 * 0.0e4
parameters dwvsatn_rf3= - a1n_rf3 * fac_n_rf3 * 0.0e-3
parameters deta0n_rf3=0.0 * a1n_rf3 * fac_n_rf3
parameters dleta0n_rf3= - 0.35e-9 * 0.5 * (a1n_rf3 * fac_n_rf3 - sqrt(a1n_rf3 *
+ fac_n_rf3 * a1n_rf3 * fac_n_rf3 + 1e-8))
parameters dweta0n_rf3=0
parameters dpeta0n_rf3= - 1.5e-16 * 0.5 * (a1n_rf3 * fac_n_rf3 - sqrt(a1n_rf3 *
+ fac_n_rf3 * a1n_rf3 * fac_n_rf3 + 1e-8))
parameters dnfactorn_rf3=a1n_rf3 * fac_n_rf3 * 0
parameters dlnfactorn_rf3=a1n_rf3 * fac_n_rf3 * 5e-8
parameters dwnfactorn_rf3=a1n_rf3 * fac_n_rf3 * 0
parameters dpnfactorn_rf3=a1n_rf3 * fac_n_rf3 * 0.0e-15
parameters dvoffn_rf3= - a1n_rf3 * fac_n_rf3 * 0.003
parameters dlvoffn_rf3= - a1n_rf3 * fac_n_rf3 * 1.0e-9
parameters dwvoffn_rf3= - a1n_rf3 * fac_n_rf3 * 0.7e-9
parameters dpvoffn_rf3= - a1n_rf3 * fac_n_rf3 * 1.0e-15
parameters du0p_rf3=a1p_rf3 * fac_p_rf3 * ( - 0.042e-2)
parameters dlu0p_rf3=a1p_rf3 * fac_p_rf3 * ( - 0.135e-9)
parameters dwu0p_rf3=a1p_rf3 * fac_p_rf3 * ( - 0.025e-9)
parameters dpu0p_rf3=a1p_rf3 * fac_p_rf3 * ( - 0.12e-16)
parameters dvthp_rf3=a1p_rf3 * fac_p_rf3 * ( - 0.0175)
parameters dlvthp_rf3=a1p_rf3 * fac_p_rf3 * ( - 1.47e-9)
parameters dwvthp_rf3=a1p_rf3 * fac_p_rf3 * ( - 1.3e-9)
parameters dpvthp_rf3=a1p_rf3 * fac_p_rf3 * ( - 2.3e-15)
parameters toxp_rf3=6.77e-09 + a4np_rf3 * fac_p_rf3 * 2.66e-10 * 0.5
parameters dxlp_rf3=a2np_rf3 * fac_p_rf3 * 1.33e-8 * 0.5
parameters dxwp_rf3=a3np_rf3 * fac_p_rf3 * 2.2e-8 * 0.5
parameters dk2p_rf3=a1p_rf3 * fac_p_rf3 * 0.01
parameters dlk2p_rf3=a1p_rf3 * fac_p_rf3 * 0.18e-8
parameters dvsatp_rf3= - a1p_rf3 * fac_p_rf3 * 0.00e4
parameters dwvsatp_rf3= - a1p_rf3 * fac_p_rf3 * 0.0e-3
parameters deta0p_rf3=0
parameters dleta0p_rf3= - 1e-10 * 0.5 * (a1p_rf3 * fac_p_rf3 - sqrt(a1p_rf3 * fac_p_rf3
+ * a1p_rf3 * fac_p_rf3 + 1e-8))
parameters dweta0p_rf3=0
parameters dpeta0p_rf3= - 1.2e-16 * 0.5 * (a1p_rf3 * fac_p_rf3 - sqrt(a1p_rf3 *
+ fac_p_rf3 * a1p_rf3 * fac_p_rf3 + 1e-8))
parameters dnfactorp_rf3=a1p_rf3 * fac_p_rf3 * 0
parameters dlnfactorp_rf3= - a1p_rf3 * fac_p_rf3 * 0.5e-8
parameters dwnfactorp_rf3= - a1p_rf3 * fac_p_rf3 * 0
parameters dpnfactorp_rf3=0
parameters dvoffp_rf3= - a1p_rf3 * fac_p_rf3 * 0.000
parameters dlvoffp_rf3= - a1p_rf3 * fac_p_rf3 * 0.0e-8
parameters dwvoffp_rf3= - a1p_rf3 * fac_p_rf3 * 0.0e-8
parameters dpvoffp_rf3= - a1p_rf3 * fac_p_rf3 * 0.0e-15
parameters cjn_rf3=0.0008516549
parameters cjswn_rf3=2.381308e-10
parameters cjswgn_rf3=2.856308e-10
parameters cgon_rf3=3.339e-10
parameters hdifn_rf3=2e-07
parameters rshn_rf3=6.8
parameters cjp_rf3=0.0009835445
parameters cjswp_rf3=2.119593e-10
parameters cjswgp_rf3=2.228474e-10
parameters cgop_rf3=2.9085e-10
parameters hdifp_rf3=2e-07
parameters rshp_rf3=7.2

statistics {
    mismatch {
        vary vthnmis_rf3 dist=gauss std=1/1
        vary dlnmis_rf3 dist=gauss std=1/1
        vary dwnmis_rf3 dist=gauss std=1/1
        vary toxnmis_rf3 dist=gauss std=1/1
        vary vthpmis_rf3 dist=gauss std=1/1
        vary dlpmis_rf3 dist=gauss std=1/1
        vary dwpmis_rf3 dist=gauss std=1/1
        vary toxpmis_rf3 dist=gauss std=1/1
        }
    }

include "rf018.scs" section=rf_mos33
endsection ff_rfmos33

//  ****************************  LIBRARY OF SNSP CORNER CASE  ******************************
section ss_rfmos33

parameters a1n_rf3=1
parameters a1p_rf3=1
parameters a2np_rf3=1
parameters a3np_rf3=-1
parameters a4np_rf3=1
parameters vthnmis_rf3=0
parameters dlnmis_rf3=0
parameters dwnmis_rf3=0
parameters toxnmis_rf3=0
parameters vthpmis_rf3=0
parameters dlpmis_rf3=0
parameters dwpmis_rf3=0
parameters toxpmis_rf3=0
parameters fac_n_rf3=0.3766 * 3.6
parameters fac_p_rf3=0.3766 * 3.2
parameters du0n_rf3=a1n_rf3 * fac_n_rf3 * ( - 0.125e-2)
parameters dlu0n_rf3=a1n_rf3 * fac_n_rf3 * ( - 1.35e-9)
parameters dwu0n_rf3=a1n_rf3 * fac_n_rf3 * ( - 0.25e-9)
parameters dpu0n_rf3=a1n_rf3 * fac_n_rf3 * ( - 15e-16)
parameters dvthn_rf3=a1n_rf3 * fac_n_rf3 * 0.0155
parameters dlvthn_rf3=a1n_rf3 * fac_n_rf3 * 6.2e-9
parameters dwvthn_rf3=a1n_rf3 * fac_n_rf3 * 6.0e-9
parameters dpvthn_rf3=a1n_rf3 * fac_n_rf3 * 6.8e-15
parameters toxn_rf3=6.8e-09 + a4np_rf3 * fac_n_rf3 * 2.66e-10 * 0.5
parameters dxln_rf3=a2np_rf3 * fac_n_rf3 * 1.33e-8 * 0.5
parameters dxwn_rf3=a3np_rf3 * fac_n_rf3 * 2.2e-8 * 0.5
parameters dk2n_rf3=a1n_rf3 * fac_n_rf3 * 0.008
parameters dlk2n_rf3=a1n_rf3 * fac_n_rf3 * 0.8e-8
parameters dvsatn_rf3= - a1n_rf3 * fac_n_rf3 * 0.0e4
parameters dwvsatn_rf3= - a1n_rf3 * fac_n_rf3 * 0.0e-3
parameters deta0n_rf3=0.0 * a1n_rf3 * fac_n_rf3
parameters dleta0n_rf3= - 0.35e-9 * 0.5 * (a1n_rf3 * fac_n_rf3 - sqrt(a1n_rf3 *
+ fac_n_rf3 * a1n_rf3 * fac_n_rf3 + 1e-8))
parameters dweta0n_rf3=0
parameters dpeta0n_rf3= - 1.5e-16 * 0.5 * (a1n_rf3 * fac_n_rf3 - sqrt(a1n_rf3 *
+ fac_n_rf3 * a1n_rf3 * fac_n_rf3 + 1e-8))
parameters dnfactorn_rf3=a1n_rf3 * fac_n_rf3 * 0
parameters dlnfactorn_rf3=a1n_rf3 * fac_n_rf3 * 5e-8
parameters dwnfactorn_rf3=a1n_rf3 * fac_n_rf3 * 0
parameters dpnfactorn_rf3=a1n_rf3 * fac_n_rf3 * 0.0e-15
parameters dvoffn_rf3= - a1n_rf3 * fac_n_rf3 * 0.003
parameters dlvoffn_rf3= - a1n_rf3 * fac_n_rf3 * 1.0e-9
parameters dwvoffn_rf3= - a1n_rf3 * fac_n_rf3 * 0.7e-9
parameters dpvoffn_rf3= - a1n_rf3 * fac_n_rf3 * 1.0e-15
parameters du0p_rf3=a1p_rf3 * fac_p_rf3 * ( - 0.042e-2)
parameters dlu0p_rf3=a1p_rf3 * fac_p_rf3 * ( - 0.135e-9)
parameters dwu0p_rf3=a1p_rf3 * fac_p_rf3 * ( - 0.025e-9)
parameters dpu0p_rf3=a1p_rf3 * fac_p_rf3 * ( - 0.12e-16)
parameters dvthp_rf3=a1p_rf3 * fac_p_rf3 * ( - 0.0175)
parameters dlvthp_rf3=a1p_rf3 * fac_p_rf3 * ( - 1.47e-9)
parameters dwvthp_rf3=a1p_rf3 * fac_p_rf3 * ( - 1.3e-9)
parameters dpvthp_rf3=a1p_rf3 * fac_p_rf3 * ( - 2.3e-15)
parameters toxp_rf3=6.77e-09 + a4np_rf3 * fac_p_rf3 * 2.66e-10 * 0.5
parameters dxlp_rf3=a2np_rf3 * fac_p_rf3 * 1.33e-8 * 0.5
parameters dxwp_rf3=a3np_rf3 * fac_p_rf3 * 2.2e-8 * 0.5
parameters dk2p_rf3=a1p_rf3 * fac_p_rf3 * 0.01
parameters dlk2p_rf3=a1p_rf3 * fac_p_rf3 * 0.18e-8
parameters dvsatp_rf3= - a1p_rf3 * fac_p_rf3 * 0.00e4
parameters dwvsatp_rf3= - a1p_rf3 * fac_p_rf3 * 0.0e-3
parameters deta0p_rf3=0
parameters dleta0p_rf3= - 1e-10 * 0.5 * (a1p_rf3 * fac_p_rf3 - sqrt(a1p_rf3 * fac_p_rf3
+ * a1p_rf3 * fac_p_rf3 + 1e-8))
parameters dweta0p_rf3=0
parameters dpeta0p_rf3= - 1.2e-16 * 0.5 * (a1p_rf3 * fac_p_rf3 - sqrt(a1p_rf3 *
+ fac_p_rf3 * a1p_rf3 * fac_p_rf3 + 1e-8))
parameters dnfactorp_rf3=a1p_rf3 * fac_p_rf3 * 0
parameters dlnfactorp_rf3= - a1p_rf3 * fac_p_rf3 * 0.5e-8
parameters dwnfactorp_rf3= - a1p_rf3 * fac_p_rf3 * 0
parameters dpnfactorp_rf3=0
parameters dvoffp_rf3= - a1p_rf3 * fac_p_rf3 * 0.000
parameters dlvoffp_rf3= - a1p_rf3 * fac_p_rf3 * 0.0e-8
parameters dwvoffp_rf3= - a1p_rf3 * fac_p_rf3 * 0.0e-8
parameters dpvoffp_rf3= - a1p_rf3 * fac_p_rf3 * 0.0e-15
parameters cjn_rf3=0.0009413027
parameters cjswn_rf3=2.631972e-10
parameters cjswgn_rf3=3.156972e-10
parameters cgon_rf3=3.021e-10
parameters hdifn_rf3=2e-07
parameters rshn_rf3=6.8
parameters cjp_rf3=0.001087076
parameters cjswp_rf3=2.342708e-10
parameters cjswgp_rf3=2.46305e-10
parameters cgop_rf3=2.6315e-10
parameters hdifp_rf3=2e-07
parameters rshp_rf3=7.2

statistics {
    mismatch {
        vary vthnmis_rf3 dist=gauss std=1/1
        vary dlnmis_rf3 dist=gauss std=1/1
        vary dwnmis_rf3 dist=gauss std=1/1
        vary toxnmis_rf3 dist=gauss std=1/1
        vary vthpmis_rf3 dist=gauss std=1/1
        vary dlpmis_rf3 dist=gauss std=1/1
        vary dwpmis_rf3 dist=gauss std=1/1
        vary toxpmis_rf3 dist=gauss std=1/1
        }
    }

include "rf018.scs" section=rf_mos33
endsection ss_rfmos33

//  ****************************  LIBRARY OF SNFP CORNER CASE  ******************************
section sf_rfmos33

parameters a1n_rf3=1
parameters a1p_rf3=-1
parameters a2np_rf3=0
parameters a3np_rf3=0
parameters a4np_rf3=0
parameters vthnmis_rf3=0
parameters dlnmis_rf3=0
parameters dwnmis_rf3=0
parameters toxnmis_rf3=0
parameters vthpmis_rf3=0
parameters dlpmis_rf3=0
parameters dwpmis_rf3=0
parameters toxpmis_rf3=0
parameters fac_n_rf3=0.3766 * 3.6
parameters fac_p_rf3=0.3766 * 3.2
parameters du0n_rf3=a1n_rf3 * fac_n_rf3 * ( - 0.125e-2)
parameters dlu0n_rf3=a1n_rf3 * fac_n_rf3 * ( - 1.35e-9)
parameters dwu0n_rf3=a1n_rf3 * fac_n_rf3 * ( - 0.25e-9)
parameters dpu0n_rf3=a1n_rf3 * fac_n_rf3 * ( - 15e-16)
parameters dvthn_rf3=a1n_rf3 * fac_n_rf3 * 0.0155
parameters dlvthn_rf3=a1n_rf3 * fac_n_rf3 * 6.2e-9
parameters dwvthn_rf3=a1n_rf3 * fac_n_rf3 * 6.0e-9
parameters dpvthn_rf3=a1n_rf3 * fac_n_rf3 * 6.8e-15
parameters toxn_rf3=6.8e-09 + a4np_rf3 * fac_n_rf3 * 2.66e-10 * 0.5
parameters dxln_rf3=a2np_rf3 * fac_n_rf3 * 1.33e-8 * 0.5
parameters dxwn_rf3=a3np_rf3 * fac_n_rf3 * 2.2e-8 * 0.5
parameters dk2n_rf3=a1n_rf3 * fac_n_rf3 * 0.008
parameters dlk2n_rf3=a1n_rf3 * fac_n_rf3 * 0.8e-8
parameters dvsatn_rf3= - a1n_rf3 * fac_n_rf3 * 0.0e4
parameters dwvsatn_rf3= - a1n_rf3 * fac_n_rf3 * 0.0e-3
parameters deta0n_rf3=0.0 * a1n_rf3 * fac_n_rf3
parameters dleta0n_rf3= - 0.35e-9 * 0.5 * (a1n_rf3 * fac_n_rf3 - sqrt(a1n_rf3 *
+ fac_n_rf3 * a1n_rf3 * fac_n_rf3 + 1e-8))
parameters dweta0n_rf3=0
parameters dpeta0n_rf3= - 1.5e-16 * 0.5 * (a1n_rf3 * fac_n_rf3 - sqrt(a1n_rf3 *
+ fac_n_rf3 * a1n_rf3 * fac_n_rf3 + 1e-8))
parameters dnfactorn_rf3=a1n_rf3 * fac_n_rf3 * 0
parameters dlnfactorn_rf3=a1n_rf3 * fac_n_rf3 * 5e-8
parameters dwnfactorn_rf3=a1n_rf3 * fac_n_rf3 * 0
parameters dpnfactorn_rf3=a1n_rf3 * fac_n_rf3 * 0.0e-15
parameters dvoffn_rf3= - a1n_rf3 * fac_n_rf3 * 0.003
parameters dlvoffn_rf3= - a1n_rf3 * fac_n_rf3 * 1.0e-9
parameters dwvoffn_rf3= - a1n_rf3 * fac_n_rf3 * 0.7e-9
parameters dpvoffn_rf3= - a1n_rf3 * fac_n_rf3 * 1.0e-15
parameters du0p_rf3=a1p_rf3 * fac_p_rf3 * ( - 0.042e-2)
parameters dlu0p_rf3=a1p_rf3 * fac_p_rf3 * ( - 0.135e-9)
parameters dwu0p_rf3=a1p_rf3 * fac_p_rf3 * ( - 0.025e-9)
parameters dpu0p_rf3=a1p_rf3 * fac_p_rf3 * ( - 0.12e-16)
parameters dvthp_rf3=a1p_rf3 * fac_p_rf3 * ( - 0.0175)
parameters dlvthp_rf3=a1p_rf3 * fac_p_rf3 * ( - 1.47e-9)
parameters dwvthp_rf3=a1p_rf3 * fac_p_rf3 * ( - 1.3e-9)
parameters dpvthp_rf3=a1p_rf3 * fac_p_rf3 * ( - 2.3e-15)
parameters toxp_rf3=6.77e-09 + a4np_rf3 * fac_p_rf3 * 2.66e-10 * 0.5
parameters dxlp_rf3=a2np_rf3 * fac_p_rf3 * 1.33e-8 * 0.5
parameters dxwp_rf3=a3np_rf3 * fac_p_rf3 * 2.2e-8 * 0.5
parameters dk2p_rf3=a1p_rf3 * fac_p_rf3 * 0.01
parameters dlk2p_rf3=a1p_rf3 * fac_p_rf3 * 0.18e-8
parameters dvsatp_rf3= - a1p_rf3 * fac_p_rf3 * 0.00e4
parameters dwvsatp_rf3= - a1p_rf3 * fac_p_rf3 * 0.0e-3
parameters deta0p_rf3=0
parameters dleta0p_rf3= - 1e-10 * 0.5 * (a1p_rf3 * fac_p_rf3 - sqrt(a1p_rf3 * fac_p_rf3
+ * a1p_rf3 * fac_p_rf3 + 1e-8))
parameters dweta0p_rf3=0
parameters dpeta0p_rf3= - 1.2e-16 * 0.5 * (a1p_rf3 * fac_p_rf3 - sqrt(a1p_rf3 *
+ fac_p_rf3 * a1p_rf3 * fac_p_rf3 + 1e-8))
parameters dnfactorp_rf3=a1p_rf3 * fac_p_rf3 * 0
parameters dlnfactorp_rf3= - a1p_rf3 * fac_p_rf3 * 0.5e-8
parameters dwnfactorp_rf3= - a1p_rf3 * fac_p_rf3 * 0
parameters dpnfactorp_rf3=0
parameters dvoffp_rf3= - a1p_rf3 * fac_p_rf3 * 0.000
parameters dlvoffp_rf3= - a1p_rf3 * fac_p_rf3 * 0.0e-8
parameters dwvoffp_rf3= - a1p_rf3 * fac_p_rf3 * 0.0e-8
parameters dpvoffp_rf3= - a1p_rf3 * fac_p_rf3 * 0.0e-15
parameters cjn_rf3=0.0009413027
parameters cjswn_rf3=2.631972e-10
parameters cjswgn_rf3=3.156972e-10
parameters cgon_rf3=3.18e-10
parameters hdifn_rf3=2e-07
parameters rshn_rf3=6.8
parameters cjp_rf3=0.0009835445
parameters cjswp_rf3=2.119593e-10
parameters cjswgp_rf3=2.228474e-10
parameters cgop_rf3=2.77e-10
parameters hdifp_rf3=2e-07
parameters rshp_rf3=7.2

statistics {
    mismatch {
        vary vthnmis_rf3 dist=gauss std=1/1
        vary dlnmis_rf3 dist=gauss std=1/1
        vary dwnmis_rf3 dist=gauss std=1/1
        vary toxnmis_rf3 dist=gauss std=1/1
        vary vthpmis_rf3 dist=gauss std=1/1
        vary dlpmis_rf3 dist=gauss std=1/1
        vary dwpmis_rf3 dist=gauss std=1/1
        vary toxpmis_rf3 dist=gauss std=1/1
        }
    }

include "rf018.scs" section=rf_mos33
endsection sf_rfmos33

//  ****************************  LIBRARY OF FNSP CORNER CASE  ******************************
section fs_rfmos33

parameters a1n_rf3=-1
parameters a1p_rf3=1
parameters a2np_rf3=0
parameters a3np_rf3=0
parameters a4np_rf3=0
parameters vthnmis_rf3=0
parameters dlnmis_rf3=0
parameters dwnmis_rf3=0
parameters toxnmis_rf3=0
parameters vthpmis_rf3=0
parameters dlpmis_rf3=0
parameters dwpmis_rf3=0
parameters toxpmis_rf3=0
parameters fac_n_rf3=0.3766 * 3.6
parameters fac_p_rf3=0.3766 * 3.2
parameters du0n_rf3=a1n_rf3 * fac_n_rf3 * ( - 0.125e-2)
parameters dlu0n_rf3=a1n_rf3 * fac_n_rf3 * ( - 1.35e-9)
parameters dwu0n_rf3=a1n_rf3 * fac_n_rf3 * ( - 0.25e-9)
parameters dpu0n_rf3=a1n_rf3 * fac_n_rf3 * ( - 15e-16)
parameters dvthn_rf3=a1n_rf3 * fac_n_rf3 * 0.0155
parameters dlvthn_rf3=a1n_rf3 * fac_n_rf3 * 6.2e-9
parameters dwvthn_rf3=a1n_rf3 * fac_n_rf3 * 6.0e-9
parameters dpvthn_rf3=a1n_rf3 * fac_n_rf3 * 6.8e-15
parameters toxn_rf3=6.8e-09 + a4np_rf3 * fac_n_rf3 * 2.66e-10 * 0.5
parameters dxln_rf3=a2np_rf3 * fac_n_rf3 * 1.33e-8 * 0.5
parameters dxwn_rf3=a3np_rf3 * fac_n_rf3 * 2.2e-8 * 0.5
parameters dk2n_rf3=a1n_rf3 * fac_n_rf3 * 0.008
parameters dlk2n_rf3=a1n_rf3 * fac_n_rf3 * 0.8e-8
parameters dvsatn_rf3= - a1n_rf3 * fac_n_rf3 * 0.0e4
parameters dwvsatn_rf3= - a1n_rf3 * fac_n_rf3 * 0.0e-3
parameters deta0n_rf3=0.0 * a1n_rf3 * fac_n_rf3
parameters dleta0n_rf3= - 0.35e-9 * 0.5 * (a1n_rf3 * fac_n_rf3 - sqrt(a1n_rf3 *
+ fac_n_rf3 * a1n_rf3 * fac_n_rf3 + 1e-8))
parameters dweta0n_rf3=0
parameters dpeta0n_rf3= - 1.5e-16 * 0.5 * (a1n_rf3 * fac_n_rf3 - sqrt(a1n_rf3 *
+ fac_n_rf3 * a1n_rf3 * fac_n_rf3 + 1e-8))
parameters dnfactorn_rf3=a1n_rf3 * fac_n_rf3 * 0
parameters dlnfactorn_rf3=a1n_rf3 * fac_n_rf3 * 5e-8
parameters dwnfactorn_rf3=a1n_rf3 * fac_n_rf3 * 0
parameters dpnfactorn_rf3=a1n_rf3 * fac_n_rf3 * 0.0e-15
parameters dvoffn_rf3= - a1n_rf3 * fac_n_rf3 * 0.003
parameters dlvoffn_rf3= - a1n_rf3 * fac_n_rf3 * 1.0e-9
parameters dwvoffn_rf3= - a1n_rf3 * fac_n_rf3 * 0.7e-9
parameters dpvoffn_rf3= - a1n_rf3 * fac_n_rf3 * 1.0e-15
parameters du0p_rf3=a1p_rf3 * fac_p_rf3 * ( - 0.042e-2)
parameters dlu0p_rf3=a1p_rf3 * fac_p_rf3 * ( - 0.135e-9)
parameters dwu0p_rf3=a1p_rf3 * fac_p_rf3 * ( - 0.025e-9)
parameters dpu0p_rf3=a1p_rf3 * fac_p_rf3 * ( - 0.12e-16)
parameters dvthp_rf3=a1p_rf3 * fac_p_rf3 * ( - 0.0175)
parameters dlvthp_rf3=a1p_rf3 * fac_p_rf3 * ( - 1.47e-9)
parameters dwvthp_rf3=a1p_rf3 * fac_p_rf3 * ( - 1.3e-9)
parameters dpvthp_rf3=a1p_rf3 * fac_p_rf3 * ( - 2.3e-15)
parameters toxp_rf3=6.77e-09 + a4np_rf3 * fac_p_rf3 * 2.66e-10 * 0.5
parameters dxlp_rf3=a2np_rf3 * fac_p_rf3 * 1.33e-8 * 0.5
parameters dxwp_rf3=a3np_rf3 * fac_p_rf3 * 2.2e-8 * 0.5
parameters dk2p_rf3=a1p_rf3 * fac_p_rf3 * 0.01
parameters dlk2p_rf3=a1p_rf3 * fac_p_rf3 * 0.18e-8
parameters dvsatp_rf3= - a1p_rf3 * fac_p_rf3 * 0.00e4
parameters dwvsatp_rf3= - a1p_rf3 * fac_p_rf3 * 0.0e-3
parameters deta0p_rf3=0
parameters dleta0p_rf3= - 1e-10 * 0.5 * (a1p_rf3 * fac_p_rf3 - sqrt(a1p_rf3 * fac_p_rf3
+ * a1p_rf3 * fac_p_rf3 + 1e-8))
parameters dweta0p_rf3=0
parameters dpeta0p_rf3= - 1.2e-16 * 0.5 * (a1p_rf3 * fac_p_rf3 - sqrt(a1p_rf3 *
+ fac_p_rf3 * a1p_rf3 * fac_p_rf3 + 1e-8))
parameters dnfactorp_rf3=a1p_rf3 * fac_p_rf3 * 0
parameters dlnfactorp_rf3= - a1p_rf3 * fac_p_rf3 * 0.5e-8
parameters dwnfactorp_rf3= - a1p_rf3 * fac_p_rf3 * 0
parameters dpnfactorp_rf3=0
parameters dvoffp_rf3= - a1p_rf3 * fac_p_rf3 * 0.000
parameters dlvoffp_rf3= - a1p_rf3 * fac_p_rf3 * 0.0e-8
parameters dwvoffp_rf3= - a1p_rf3 * fac_p_rf3 * 0.0e-8
parameters dpvoffp_rf3= - a1p_rf3 * fac_p_rf3 * 0.0e-15
parameters cjn_rf3=0.0008516549
parameters cjswn_rf3=2.381308e-10
parameters cjswgn_rf3=2.856308e-10
parameters cgon_rf3=3.18e-10
parameters hdifn_rf3=2e-07
parameters rshn_rf3=6.8
parameters cjp_rf3=0.001087076
parameters cjswp_rf3=2.342708e-10
parameters cjswgp_rf3=2.46305e-10
parameters cgop_rf3=2.77e-10
parameters hdifp_rf3=2e-07
parameters rshp_rf3=7.2

statistics {
    mismatch {
        vary vthnmis_rf3 dist=gauss std=1/1
        vary dlnmis_rf3 dist=gauss std=1/1
        vary dwnmis_rf3 dist=gauss std=1/1
        vary toxnmis_rf3 dist=gauss std=1/1
        vary vthpmis_rf3 dist=gauss std=1/1
        vary dlpmis_rf3 dist=gauss std=1/1
        vary dwpmis_rf3 dist=gauss std=1/1
        vary toxpmis_rf3 dist=gauss std=1/1
        }
    }

include "rf018.scs" section=rf_mos33
endsection fs_rfmos33

//  ****************************    LIBRARY OF statistical model    ******************************

section mc_rfmos33

parameters vthnmis_rf3=0
parameters dlnmis_rf3=0
parameters dwnmis_rf3=0
parameters toxnmis_rf3=0
parameters vthpmis_rf3=0
parameters dlpmis_rf3=0
parameters dwpmis_rf3=0
parameters toxpmis_rf3=0
parameters par1_rf3=0
parameters par2_rf3=0
parameters par3_rf3=0
parameters par4_rf3=0
parameters par5_rf3=0
parameters a1n_rf3=par1_rf3
parameters a1p_rf3=par2_rf3
parameters a2np_rf3=par3_rf3
parameters a3np_rf3=par4_rf3
parameters a4np_rf3=par5_rf3
parameters fac_n_rf3=3.6
parameters fac_p_rf3=3.2
parameters du0n_rf3=a1n_rf3 * fac_n_rf3 * ( - 0.05e-2) + a4np_rf3 * fac_n_rf3 *
+ ( - 0.02e-2)
parameters dlu0n_rf3=a1n_rf3 * fac_n_rf3 * ( - 0.8e-9)
parameters dwu0n_rf3=a1n_rf3 * fac_n_rf3 * ( - 0.11e-9)
parameters dpu0n_rf3=a1n_rf3 * fac_n_rf3 * ( - 4e-16)
parameters dvthn_rf3=a1n_rf3 * fac_n_rf3 * 0.009
parameters dlvthn_rf3=a1n_rf3 * fac_n_rf3 * 3.0e-9
parameters dwvthn_rf3=a1n_rf3 * fac_n_rf3 * 2.3e-9
parameters dpvthn_rf3=a1n_rf3 * fac_n_rf3 * 1.1e-15
parameters toxn_rf3=6.8e-09 + a4np_rf3 * fac_n_rf3 * 0.5e-10
parameters dxln_rf3=a2np_rf3 * fac_n_rf3 * 0.8e-8
parameters dxwn_rf3=a3np_rf3 * fac_n_rf3 * 1.20e-8
parameters dk2n_rf3=a1n_rf3 * fac_n_rf3 * 0.0047 + a4np_rf3 * fac_n_rf3 * 0.0004
parameters dlk2n_rf3=a1n_rf3 * fac_n_rf3 * 0.28e-8 + a4np_rf3 * fac_n_rf3 * 0.15e-8
parameters dvsatn_rf3= - a1n_rf3 * fac_n_rf3 * 0.030e4
parameters dwvsatn_rf3= - a1n_rf3 * fac_n_rf3 * 0.9e-3
parameters deta0n_rf3=0.0 * a1n_rf3 * fac_n_rf3
parameters dleta0n_rf3= - 0.0e-10 * 0.5 * (a1n_rf3 * fac_n_rf3 - sqrt(a1n_rf3 *
+ fac_n_rf3 * a1n_rf3 * fac_n_rf3 + 1e-8)) - 1.0e-10 * 0.5 * (a2np_rf3 * fac_n_rf3
+ - sqrt(a2np_rf3 * fac_n_rf3 * a2np_rf3 * fac_n_rf3 + 1e-8))
parameters dweta0n_rf3= - 1e-9 * 0.5 * (a1n_rf3 * fac_n_rf3 - sqrt(a1n_rf3 * fac_n_rf3
+ * a1n_rf3 * fac_n_rf3 + 1e-4)) * 0
parameters dpeta0n_rf3= - 0.0e-16 * 0.5 * (a1n_rf3 * fac_n_rf3 - sqrt(a1n_rf3 *
+ fac_n_rf3 * a1n_rf3 * fac_n_rf3 + 1e-8)) - 0.4e-16 * 0.5 * (a2np_rf3 * fac_n_rf3
+ - sqrt(a2np_rf3 * fac_n_rf3 * a2np_rf3 * fac_n_rf3 + 1e-8)) + 0.4e-16 * 0.5 *
+ (a3np_rf3 * fac_n_rf3 + sqrt(a3np_rf3 * fac_n_rf3 * a3np_rf3 * fac_n_rf3 + 1e-8))
parameters dnfactorn_rf3=0
parameters dlnfactorn_rf3=a1n_rf3 * fac_n_rf3 * 1.5e-8 + a2np_rf3 * fac_n_rf3 *
+ 1.1e-8
parameters dwnfactorn_rf3=0
parameters dpnfactorn_rf3=a1n_rf3 * fac_n_rf3 * 0.6e-15 + a2np_rf3 * fac_n_rf3 *
+ 1.2e-15 - a3np_rf3 * fac_n_rf3 * 1.2e-15
parameters dvoffn_rf3= - a1n_rf3 * fac_n_rf3 * 0.000
parameters dlvoffn_rf3= - a1n_rf3 * fac_n_rf3 * 0.04e-8
parameters dwvoffn_rf3= - a1n_rf3 * fac_n_rf3 * 0.05e-8
parameters dpvoffn_rf3=a1n_rf3 * fac_n_rf3 * 1.0e-15 - a2np_rf3 * fac_n_rf3 * 0.55e-15
+ + a3np_rf3 * fac_n_rf3 * 0.55e-15
parameters du0p_rf3=a1p_rf3 * fac_p_rf3 * ( - 0.00e-2) + a4np_rf3 * fac_p_rf3 *
+ ( - 0.01e-2)
parameters dlu0p_rf3=a1p_rf3 * fac_p_rf3 * ( - 0.07e-9)
parameters dwu0p_rf3=a1p_rf3 * fac_p_rf3 * ( - 0.00e-9)
parameters dpu0p_rf3=a1p_rf3 * fac_p_rf3 * ( - 0.1e-16)
parameters dvthp_rf3=a1p_rf3 * fac_p_rf3 * ( - 0.005)
parameters dlvthp_rf3=a1p_rf3 * fac_p_rf3 * ( - 0.6e-9)
parameters dwvthp_rf3=a1p_rf3 * fac_p_rf3 * ( - 2.0e-9)
parameters dpvthp_rf3=a1p_rf3 * fac_p_rf3 * ( - 0.6e-15)
parameters toxp_rf3=6.77e-09 + a4np_rf3 * fac_p_rf3 * 1.0e-10
parameters dxlp_rf3=a2np_rf3 * fac_p_rf3 * 0.8e-8
parameters dxwp_rf3=a3np_rf3 * fac_p_rf3 * 1.20e-8
parameters dk2p_rf3=a1p_rf3 * fac_p_rf3 * 0.003 + a4np_rf3 * fac_p_rf3 * 0.002
parameters dlk2p_rf3=a1p_rf3 * fac_p_rf3 * 0.08e-8 + a4np_rf3 * fac_p_rf3 * 0.04e-8
parameters dvsatp_rf3= - a1p_rf3 * fac_p_rf3 * 0.000e4
parameters dwvsatp_rf3= - a1p_rf3 * fac_p_rf3 * 0.2e-3
parameters deta0p_rf3=0
parameters dleta0p_rf3= - 0e-10 * 0.5 * (a1p_rf3 * fac_p_rf3 - sqrt(a1p_rf3 * fac_p_rf3
+ * a1p_rf3 * fac_p_rf3 + 1e-8)) - 0.4e-10 * 0.5 * (a2np_rf3 * fac_p_rf3 - sqrt(a2np_rf3
+ * fac_p_rf3 * a2np_rf3 * fac_p_rf3 + 1e-8))
parameters dweta0p_rf3=0
parameters dpeta0p_rf3= - 0.2e-16 * 0.5 * (a1p_rf3 * fac_p_rf3 - sqrt(a1p_rf3 *
+ fac_p_rf3 * a1p_rf3 * fac_p_rf3 + 1e-8)) - 0.18e-16 * 0.5 * (a2np_rf3 * fac_p_rf3
+ - sqrt(a2np_rf3 * fac_p_rf3 * a2np_rf3 * fac_p_rf3 + 1e-8)) + 0.18e-16 * 0.5 *
+ (a3np_rf3 * fac_p_rf3 + sqrt(a3np_rf3 * fac_p_rf3 * a3np_rf3 * fac_p_rf3 + 1e-8))
parameters dnfactorp_rf3=a1p_rf3 * fac_p_rf3 * 0
parameters dlnfactorp_rf3= - a1p_rf3 * fac_p_rf3 * 1.0e-8 + a2np_rf3 * fac_p_rf3
+ * 1.5e-8
parameters dwnfactorp_rf3= - a1p_rf3 * fac_p_rf3 * 0
parameters dpnfactorp_rf3=0
parameters dvoffp_rf3= - a1p_rf3 * fac_p_rf3 * 0.002
parameters dlvoffp_rf3=a1p_rf3 * fac_p_rf3 * 0.15e-8
parameters dwvoffp_rf3= - a1p_rf3 * fac_p_rf3 * 0.4e-8
parameters dpvoffp_rf3=a1p_rf3 * fac_p_rf3 * 1.0e-15 - a2np_rf3 * fac_p_rf3 * 0.2e-15
+ + a3np_rf3 * fac_p_rf3 * 0.2e-15
parameters cjn_rf3=0.0008964788 * (1 + 0.05 * a1n_rf3)
parameters cjswn_rf3=2.50664e-10 * (1 + 0.05 * a1n_rf3)
parameters cjswgn_rf3=3.00664e-10 * (1 + 0.05 * a1n_rf3)
parameters cgon_rf3=3.18e-10 * (1 - 0.05 * a4np_rf3)
parameters hdifn_rf3=2e-07
parameters rshn_rf3=6.8
parameters cjp_rf3=0.00103531 * (1 + 0.05 * a1p_rf3)
parameters cjswp_rf3=2.23115e-10 * (1 + 0.05 * a1p_rf3)
parameters cjswgp_rf3=2.345762e-10 * (1 + 0.05 * a1p_rf3)
parameters cgop_rf3=2.77e-10 * (1 - 0.05 * a4np_rf3)
parameters hdifp_rf3=2e-07
parameters rshp_rf3=7.2

statistics {
    process {
        vary par1_rf3 dist=gauss std=1/6
        vary par2_rf3 dist=gauss std=1/6
        vary par3_rf3 dist=gauss std=1/6
        vary par4_rf3 dist=gauss std=1/6
        vary par5_rf3 dist=gauss std=1/6
        }
    mismatch {
        vary vthnmis_rf3 dist=gauss std=1/1
        vary dlnmis_rf3 dist=gauss std=1/1
        vary dwnmis_rf3 dist=gauss std=1/1
        vary toxnmis_rf3 dist=gauss std=1/1
        vary vthpmis_rf3 dist=gauss std=1/1
        vary dlpmis_rf3 dist=gauss std=1/1
        vary dwpmis_rf3 dist=gauss std=1/1
        vary toxpmis_rf3 dist=gauss std=1/1
        }
    }

include "rf018.scs" section=rf_mos33
endsection mc_rfmos33

//*******************************************************************
//******************* MIM Corner Parameters *************************
//*******************************************************************

section tt_rfmim
parameters ct_mimfac=1.0
+ cb_mimfac=1.0
+ l_mimfac=1.0
+ cmim_mimfac=1.0
+ cm5_mimfac=1.0
+ rsub_mimfac=1.0
+ csub_mimfac=1.0
+ rctm_mimfac=1.0
include "rf018.scs" section=rf_mim
endsection tt_rfmim

section ff_rfmim
parameters ct_mimfac=1.0
+ cb_mimfac=1.0
+ l_mimfac=0.9762
+ cmim_mimfac=0.85
+ cm5_mimfac=0.9538
+ rsub_mimfac=1.2
+ csub_mimfac=0.8333
+ rctm_mimfac=0.8273
include "rf018.scs" section=rf_mim
endsection ff_rfmim

section ss_rfmim
parameters ct_mimfac=1.0
+ cb_mimfac=1.0
+ l_mimfac=1.0235
+ cmim_mimfac=1.15
+ cm5_mimfac=1.052
+ rsub_mimfac=0.8
+ csub_mimfac=1.25
+ rctm_mimfac=1.1727
include "rf018.scs" section=rf_mim
endsection ss_rfmim

//*******************************************************************
//******************* Inductor Corner Parameters ********************
//*******************************************************************

section tt_rfind
parameters c12_indfac=1.0
+ rm6_indfac=1.0
+ l_indfac=1.0
+ k_indfac=1.0
+ rsm6_indfac=1.0
+ lsm6_indfac=1.0
+ cm6_indfac=1.0
+ csub_indfac=1.0
+ rsub_indfac=1.0
+ rm5_indfac=1.0
+ lm5_indfac=1.0
include "rf018.scs" section=rf_ind
endsection tt_rfind

section ff_rfind
parameters c12_indfac=0.7764
+ rm6_indfac=0.9
+ l_indfac=0.9762
+ k_indfac=0.9762
+ rsm6_indfac=0.9
+ lsm6_indfac=0.9762
+ cm6_indfac=0.9551
+ csub_indfac=0.8333
+ rsub_indfac=1.2
+ rm5_indfac=0.9
+ lm5_indfac=0.9762
include "rf018.scs" section=rf_ind
endsection ff_rfind

section ss_rfind
parameters c12_indfac=1.2236
+ rm6_indfac=1.1
+ l_indfac=1.0235
+ k_indfac=1.0235
+ rsm6_indfac=1.1
+ lsm6_indfac=1.0235
+ cm6_indfac=1.0509
+ csub_indfac=1.25
+ rsub_indfac=0.8
+ rm5_indfac=1.1
+ lm5_indfac=1.0235
include "rf018.scs" section=rf_ind
endsection ss_rfind

//*******************************************************************
//******************* MOS Varactor Corner Parameters ****************
//*******************************************************************

section tt_rfmvar
parameters l_mvfac=1
parameters rm1_mvfac=1
parameters rsub_mvfac=1
parameters csub_mvfac=1
parameters cj_mvfac=1
parameters rnpolys_mvfac=1
parameters cmv_fac=1
include "rf018.scs" section=rf_mvar
endsection tt_rfmvar

section ff_rfmvar
parameters l_mvfac=0.9765
parameters rm1_mvfac=0.8043
parameters rsub_mvfac=1.2
parameters csub_mvfac=0.8333
parameters cj_mvfac=0.9500
parameters rnpolys_mvfac=0.5088
parameters cmv_fac=0.9556
include "rf018.scs" section=rf_mvar
endsection ff_rfmvar

section ss_rfmvar
parameters l_mvfac=1.0235
parameters rm1_mvfac=1.1966
parameters rsub_mvfac=0.8000
parameters csub_mvfac=1.2500
parameters cj_mvfac=1.0500
parameters rnpolys_mvfac=1.4912
parameters cmv_fac=1.0444
include "rf018.scs" section=rf_mvar
endsection ss_rfmvar

//*******************************************************************
//******************* Xj Varactor Corner Parameters *****************
//*******************************************************************
section tt_rfjvar
parameters xjl_fac=1
parameters xjrm1_fac=1
parameters xjrsub_fac=1
parameters xjcsub_fac=1
parameters xjdio_cjfac=1
include "rf018.scs" section=rf_jvar
endsection tt_rfjvar

section ff_rfjvar
parameters xjl_fac=0.9765
parameters xjrm1_fac=0.8043
parameters xjrsub_fac=1.2
parameters xjcsub_fac=0.8333
parameters xjdio_cjfac=0.9500
include "rf018.scs" section=rf_jvar
endsection ff_rfjvar

section ss_rfjvar
parameters xjl_fac=1.0235
parameters xjrm1_fac=1.1966
parameters xjrsub_fac=0.8000
parameters xjcsub_fac=1.2500
parameters xjdio_cjfac=1.0500
include "rf018.scs" section=rf_jvar
endsection ss_rfjvar

//*******************************************************************
//******************* Resistor Corner Parameters ********************
//*******************************************************************
section tt_rfres_sa
parameters rppoly = 7.9
parameters sal_fac = 1
parameters sacox_fac = 1
include "rf018.scs" section=rf_res_sa
endsection tt_rfres_sa

section ff_rfres_sa
parameters rppoly = 5.4
parameters sal_fac = 0.9765
parameters sacox_fac = 0.8550
include "rf018.scs" section=rf_res_sa
endsection ff_rfres_sa

section ss_rfres_sa
parameters rppoly = 10.4
parameters sal_fac = 1.0235
parameters sacox_fac = 1.2100
include "rf018.scs" section=rf_res_sa
endsection ss_rfres_sa

//---------------------------------------

section tt_rfres_rpo
parameters rppolyrpo = 311
parameters rpol_fac = 1
parameters rpocox_fac = 1
include "rf018.scs" section=rf_res_rpo
endsection tt_rfres_rpo

section ff_rfres_rpo
parameters rppolyrpo = 264.35
parameters rpol_fac = 0.9765
parameters rpocox_fac = 0.8550
include "rf018.scs" section=rf_res_rpo
endsection ff_rfres_rpo

section ss_rfres_rpo
parameters rppolyrpo = 357.65
parameters rpol_fac = 1.0235
parameters rpocox_fac = 1.2100
include "rf018.scs" section=rf_res_rpo
endsection ss_rfres_rpo

//---------------------------------------

section tt_rfres_hri
parameters rppolyhri = 1075.37
parameters hril_fac = 1
parameters hricox_fac = 1
include "rf018.scs" section=rf_res_hri
endsection tt_rfres_hri

section ff_rfres_hri
parameters rppolyhri = 914.07
parameters hril_fac = 0.9765
parameters hricox_fac = 0.8550
include "rf018.scs" section=rf_res_hri
endsection ff_rfres_hri

section ss_rfres_hri
parameters rppolyhri = 1236.67
parameters hril_fac = 1.0235
parameters hricox_fac = 1.2100
include "rf018.scs" section=rf_res_hri
endsection ss_rfres_hri

//  ******************************************************
//  ************** ESD Corner Parameters ******************
//  ******************************************************
section tt_rfesd
parameters rm1_esdfac=1.0
parameters rpodrpo_esdfac=1.0
parameters csub_esdfac=1.0
parameters rsub_esdfac=1.0
parameters cj_esdfac=1.0
include "rf018.scs" section=rf_esd
endsection tt_rfesd

section ff_rfesd
parameters rm1_esdfac=0.8043
parameters rpodrpo_esdfac=0.8572
parameters csub_esdfac=0.8333
parameters rsub_esdfac=1.2000
parameters cj_esdfac=0.9500
include "rf018.scs" section=rf_esd
endsection ff_rfesd

section ss_rfesd
parameters rm1_esdfac=1.1966
parameters rpodrpo_esdfac=1.1428
parameters csub_esdfac=1.25
parameters rsub_esdfac=0.8000
parameters cj_esdfac=1.0500
include "rf018.scs" section=rf_esd
endsection ss_rfesd

// *************************************************************************************************

section rf_mos
//  ************************************************************************************************
//
// 1) 1.8V MOS MODEL :
//
//     SPECTRE VERSION : 5.0.33_USR2
//
//
//               .lib MOS_RF : Typical model
//
//               Model name       NF               L (um)             Wf (um)
//                             low   high        low    high      low    high
//             -----------------------------------------------------------------
//
//               nmos_rf        1     64         0.18   0.5        1.5    8
// (normal nmos)
//             -----------------------------------------------------------------
//               pmos_rf        1     64         0.18   0.5        1.5    8
// (normal pmos with DNW)
//             -----------------------------------------------------------------
//               pmos_rf_nw     1     64         0.18   0.5        1.5    8
// (normal pmos without DNW)
//             -----------------------------------------------------------------
//
//               nmos_rf_mis    1     64         0.18   0.5        1.5    8
// (mismatch nmos)
//             -----------------------------------------------------------------
//               pmos_rf_mis    1     64         0.18   0.5        1.5    8
// (mismatch pmos with DNW)
//             -----------------------------------------------------------------
//               pmos_rf_nw_mis 1     64         0.18   0.5        1.5    8
// (mismatch pmos without DNW)
//             -----------------------------------------------------------------
//
//             **NF: Finger number
//
//
//
//  ************************************************************************************************

subckt nmos_rf ( d g s b )
parameters lr=18.e-08 nr=64 wr=1.5e-6 lspace=0.54u ledge=2.6u ledgeeff=0.97u lsti=1.84u
+ wsti=3.37u rod=2570 rsti=4597 ns=int(nr / 2 + 1) nd=int((nr + 1) / 2) lod=nr *
+ (lr + lspace) + 2 * ledge - lspace rb=(rod * lod / 12 + rsti * lsti / 2) * (rod
+ * wr / 12 + rsti * wsti / 2) / (lod * (rod * lod / 12 + rsti * lsti / 2) + wr
+ * (rod * wr / 12 + rsti * wsti / 2)) rdb=rod * lr / (wr * nr * 2)
//  *******************
rg ( g gi ) resistor r=(0.539 * wr / nr / lr + 0.146 / nr / (lr * 1e6) + 17.86 /
+ nr + 584.9 * lr / nr / wr + 3.48)
rs ( s si ) resistor r=(0.0325 * (lr * 1e6 + 0.54) * (2 * ns + 1 / ns - 3) + 8.666
+ / ns + 0.4485) / (wr * 1e6)
rd ( d di ) resistor r=0.005417 * (lr * 1e6 + 0.54) * (nd + 2 / nd) + 0.0929 * (wr
+ * 1e6 + 2.94) / nd + 1.625 / (1.43 + (nd - 1) * (lr * 1e6 + 0.54))
//  *******************
cgs_m ( gi si ) capacitor c=(1.649 * nr * (lr * 1e6 + 0.54) / (0.1 * wr * 1e6 +
+ 4) + 0.158 * wr * 1e6 + 0.737) * 1e-15
cgd_m ( gi di ) capacitor c=(0.181 * nr * lr * 1e6 + 0.153 * nr + 0.331) * 1e-15
cds_m ( si di ) capacitor c=(0.0713 + 0.0842 * nr * wr * 1e6 / (lr * 1e6 + 0.9)
+ + 1.051 * nr * (lr * 1e6 + 0.54) / (wr * 1e6 + 9.8)) * 1e-15
//  *** Diodes  ****************
dss ( sb si ) ndio_rf_f area=(ns - 2) * wr * lspace + 2 * wr * ledgeeff + (nr -
+ int(nr / 2) * 2) * wr * (lspace - ledgeeff) pj=(ns - 2) * lspace * 2 + 2 * (2
+ * ledgeeff + wr) + (nr - int(nr / 2) * 2) * (2 * (lspace - ledgeeff) - wr)
ddd ( db di ) ndio_rf_f area=int(nr / 2) * wr * lspace + (nr - int(nr / 2) * 2)
+ * wr * ledgeeff pj=int(nr / 2) * lspace * 2 + (nr - int(nr / 2) * 2) * (2 * ledgeeff
+ + wr)
dsg ( sb si ) ndio_rf_g area=1e-15 pj=wr * nr
ddg ( db di ) ndio_rf_g area=1e-15 pj=wr * nr
//  ***************************************************************************
rb ( b bi ) resistor r=rb
cb ( b bi ) capacitor c=159f / rb
rdb ( db bi ) resistor r=rdb
cdb ( db bi ) capacitor c=159f / rdb
rsb ( sb bi ) resistor r=rdb
csb ( sb bi ) capacitor c=159f / rdb
//  ***** MOSFET *******
m0 ( di gi si bi ) nch_rf l=lr w=wr m=nr ad=0 as=0 pd=0 ps=0

model nch_rf bsim3v3  {
     1: type=n
+ lmin=1.8e-007             lmax=5.001e-07            wmin=1.5000e-06
+ wmax=8.001e-06            tnom=25.0                 version=3.24
+ tox=toxn_rf               toxm=4.08e-09             xj=1.6000000e-07
+ nch=3.9000000e17          lln=-1                    lwn=1.0000000
+ wln=1.0000000             wwn=-1                    lint=1.0000000e-08
+ ll=0.00                   lw=0.00                   lwl=0.00
+ wint=3.0000000e-09        wl=0.00                   ww=0.00
+ wwl=0.00                  mobmod=1                  binunit=2
+ xl=-0.02e-6+dxln_rf       xw=0.0+dxwn_rf            dwg=0.00
+ dwb=0.00                  ldif=9.00e-08             hdif=hdifn_rf
+ rsh=rshn_rf               rd=0                      rs=0
+ vth0=0.4751966+dvthn_rf   lvth0=5.3743360e-09+dlvthn_rf
+ wvth0=3.4482360e-10+dwvthn_rf                       pvth0=4.5089380e-15+dpvthn_rf
+ k1=dk1n_rf+0.4007356      lk1=4.9634880e-08         wk1=8.8686750e-08
+ pk1=-6.3891820e-15        k2=6.3188600e-02+dk2n_rf  lk2=-2.3847164e-08+dlk2n_rf
+ wk2=-3.8768180e-08        pk2=5.0552590e-15         k3=0.00
+ dvt0=0.00                 dvt1=0.00                 dvt2=0.00
+ dvt0w=0.00                dvt1w=0.00                dvt2w=0.00
+ nlx=0.00                  w0=0.00                   k3b=0.00
+ vsat=8.4294280e04+dvsatn_rf                         lvsat=-2.0140363e-04
+ wvsat=1.4459029e-03+dwvsatn_rf                      pvsat=1.5350395e-12
+ ua=-9.0172960e-10         lua=3.5887640e-18         wua=4.2784730e-16
+ pua=-4.6390690e-23        ub=2.7527719e-18          lub=5.9103390e-27
+ wub=-9.4519130e-25        pub=-3.5064990e-33        uc=1.2291169e-10
+ luc=4.3605990e-18         wuc=-6.1268420e-17        puc=-2.2654354e-24
+ rdsw=drdswn_rf+1.7000000e02                         prwb=0.00
+ prwg=0.00                 wr=1.0000000              u0=du0n_rf+4.3840840e-02
+ lu0=1.2758692e-09+dlu0n_rf                          wu0=-4.8608560e-09+dwu0n_rf
+ pu0=-2.4055863e-16+dpu0n_rf                         a0=0.5262308
+ la0=8.2795080e-08         wa0=1.4537927e-07         pa0=-7.3379640e-14
+ keta=-4.4118840e-02       lketa=3.2284670e-09       wketa=2.2941933e-08
+ pketa=-2.7027957e-15      a1=0.00                   a2=0.9900000
+ ags=-2.7693154e-02        lags=1.0727657e-09        wags=7.7723050e-08
+ pags=-1.0838496e-14       b0=0.00                   b1=0.00
+ voff=-0.1247105+dvoffn_rf lvoff=-1.4487617e-09+dlvoffn_rf
+ wvoff=1.6054964e-09+dwvoffn_rf                      pvoff=-9.7541500e-16+dpvoffn_rf
+ nfactor=1.0000000+dnfactorn_rf                      pnfactor=0+dpnfactorn_rf
+ wnfactor=0+dwnfactorn_rf  lnfactor=0+dlnfactorn_rf  cit=2.7498236e-04
+ lcit=1.0350804e-10        wcit=-3.0914837e-11       pcit=1.4220811e-17
+ cdsc=0.00                 cdscb=0.00                cdscd=0.00
+ eta0=-2.9405078e-04+deta0n_rf                       leta0=1.8126334e-10+dleta0n_rf
+ weta0=3.0046217e-12+dweta0n_rf                      peta0=-1.3821218e-18+dpeta0n_rf
+ etab=1.3878694e-03        letab=-6.8441990e-10      wetab=-3.6866540e-12
+ petab=1.6959704e-18       dsub=0.00                 pclm=1.1010191
+ lpclm=3.8489530e-08       wpclm=6.6560680e-08       ppclm=4.0427110e-14
+ pdiblc1=1.0000000e-06     pdiblc2=-6.1190130e-03    lpdiblc2=5.0530930e-09
+ wpdiblc2=1.8349379e-09    ppdiblc2=-2.2121929e-16   pdiblcb=1.0000000e-02
+ drout=0.00                pscbe1=4.0000000e08       pscbe2=1.0000000e-06
+ pvag=0.00                 delta=1.0000000e-02       alpha0=0.0
+ alpha1=0.448150714        beta0=11.59263            kt1=-0.2269240
+ lkt1=5.0937890e-09        wkt1=-2.2583577e-09       pkt1=-1.7512235e-15
+ kt2=-2.9338669e-02        lkt2=5.9558730e-10        wkt2=-1.9897783e-09
+ pkt2=7.3825670e-17        at=2.0000000e04           ute=-2.1610963
+ lute=8.2097990e-08        wute=7.8818350e-07        pute=-1.1786150e-13
+ ua1=1.2174792e-09         lua1=9.1298580e-19        wua1=7.7858620e-18
+ pua1=-1.0901051e-24       ub1=-3.8124500e-18        lub1=4.2482470e-25
+ wub1=2.8560549e-24        pub1=-4.2389140e-31       uc1=-1.5406690e-10
+ luc1=3.2328220e-17        wuc1=1.5903152e-16        puc1=-2.7204607e-23
+ kt1l=0.00
+ prt=0 cj=0 mj=0.3595262
+ pb=0.6882682 cjsw=0 mjsw=0.2003879
+ pbsw=0.6882682 cjswg=0 mjswg=0.43879
+ pbswg=0.6882682 tpb=1.554306e-03 tpbsw=1.554306e-03
+ tcj=1.040287e-03 tcjsw=6.45489e-04 js=8.38e-06
+ jsw=1.60e-11 nj=1.0 xti=3.0
+ cgdo=1.92e-10 cgso=1.92e-10 cgbo=1.0e-13
+ capmod=3 nqsmod=0 elm=0
+ xpart=0 cf=0 tlev=1
+ tlevc=1 wwc=-0.0225
+ dlc=2.68e-8 dwc=-2.833e-8 noff=2
+ lnoff=5e-8 acde=1 moin=10
+ voffcv=-0.05 lvoffcv=1.114e-8 cgsl=1.31e-10
+ cgdl=1.31e-10 wcf=2.82e-18 noimod=2
+ noia=2.0e+19 noib=1.2e4 noic=2.5e-13
+ em=3.0e+07 ef=0.874
+ minr=1e-60 imax=0.01 imelt=0.01
//  )

//  *************************************************************
//                     1.8V MODEL OF N+/PW DIODE                *
//  *************************************************************
     }

model ndio_rf_f diode level=1 tlevc=1 cj=cjn_rf mj=0.3595262 pb=0.6882682 cjsw=cjswn_rf
+ mjsw=0.2003879 vjsw=0.6882682 cta=0.001040287 ctp=0.000645489 pta=0.001554306 ptp=0.001554306

model ndio_rf_g diode level=1 tlevc=1 cj=cjn_rf mj=0.3595262 pb=0.6882682 cjsw=cjswgn_rf
+ mjsw=0.43879 vjsw=0.6882682 cta=0.001040287 ctp=0.000645489 pta=0.001554306 ptp=0.001554306

ends nmos_rf

subckt pmos_rf ( d g s b )
parameters lr=18.e-08 nr=64 wr=1.5e-6 lspace=0.54u ledge=2.6u ledgeeff=0.97u lsti=1.84u
+ wsti=3.37u rod=410 rsti=524 ns=int(nr / 2 + 1) nd=int((nr + 1) / 2) lod=nr * (lr
+ + lspace) + 2 * ledge - lspace rb=(rod * lod / 12 + rsti * lsti / 2) * (rod *
+ wr / 12 + rsti * wsti / 2) / (lod * (rod * lod / 12 + rsti * lsti / 2) + wr *
+ (rod * wr / 12 + rsti * wsti / 2)) rdb=rod * lr / (wr * nr * 2)
//  ********************
rg ( g gi ) resistor r=(1.098 * wr / nr / lr - 22.52 / nr / (lr * 1e6) + 100.15
+ / nr + 1190.3 * lr / nr / wr + 2.82)
rs ( s si ) resistor r=(0.0325 * (lr * 1e6 + 0.54) * (2 * ns + 1 / ns - 3) + 8.666
+ / ns + 0.4485) / (wr * 1e6)
rd ( d di ) resistor r=0.005417 * (lr * 1e6 + 0.54) * (nd + 2 / nd) + 0.0929 * (wr
+ * 1e6 + 2.94) / nd + 1.625 / (1.43 + (nd - 1) * (lr * 1e6 + 0.54))
//  *******************
cgs_m ( gi si ) capacitor c=(1.649 * nr * (lr * 1e6 + 0.54) / (0.1 * wr * 1e6 +
+ 4) + 0.158 * wr * 1e6 + 0.737) * 1e-15
cgd_m ( gi di ) capacitor c=(0.181 * nr * lr * 1e6 + 0.153 * nr + 0.331) * 1e-15
cds_m ( si di ) capacitor c=(0.0713 + 0.0842 * nr * wr * 1e6 / (lr * 1e6 + 0.9)
+ + 1.051 * nr * (lr * 1e6 + 0.54) / (wr * 1e6 + 9.8)) * 1e-15
//  *** Diodes  ****************
dss ( si sb ) pdio_rf_f area=(ns - 2) * wr * lspace + 2 * wr * ledgeeff + (nr -
+ int(nr / 2) * 2) * wr * (lspace - ledgeeff) pj=(ns - 2) * lspace * 2 + 2 * (2
+ * ledgeeff + wr) + (nr - int(nr / 2) * 2) * (2 * (lspace - ledgeeff) - wr)
ddd ( di db ) pdio_rf_f area=int(nr / 2) * wr * lspace + (nr - int(nr / 2) * 2)
+ * wr * ledgeeff pj=int(nr / 2) * lspace * 2 + (nr - int(nr / 2) * 2) * (2 * ledgeeff
+ + wr)
dsg ( si sb ) pdio_rf_g area=1e-15 pj=wr * nr
ddg ( di db ) pdio_rf_g area=1e-15 pj=wr * nr
//  ***************************************************************************
rb ( b bi ) resistor r=rb
cb ( b bi ) capacitor c=21.6f / rb
rdb ( db bi ) resistor r=rdb
cdb ( db bi ) capacitor c=21.6f / rdb
rsb ( sb bi ) resistor r=rdb
csb ( sb bi ) capacitor c=21.6f / rdb
//  ***** MOSFET *******
m0 ( di gi si bi ) pch_rf l=lr w=wr m=nr ad=0 as=0 pd=0 ps=0

model pch_rf bsim3v3  {
     1: type=p
+ lmin=1.8e-007             lmax=5.001e-07            wmin=1.5000e-06
+ wmax=8.001e-06            tnom=25.0                 version=3.24
+ tox=toxp_rf               toxm=4.08e-09             xj=1.7000001e-07
+ nch=3.9000000e17          lln=-1                    lwn=1.0000000
+ wln=1.0000000             wwn=-1.0000000            lint=1.4999999e-08
+ ll=0.00                   lw=0.00                   lwl=0.00
+ wint=5.0000000e-09        wl=0.00                   ww=0.00
+ wwl=0.00                  mobmod=1                  binunit=2
+ xl=-0.02e-6+dxlp_rf       xw=0.0+dxwp_rf            dwg=0.00
+ dwb=0.00                  ldif=9.00e-08             hdif=hdifp_rf
+ rsh=rshp_rf               rd=0                      rs=0
+ vth0=-0.4492160+dvthp_rf  lvth0=-8.1280260e-09+dlvthp_rf
+ wvth0=9.1421640e-09+dwvthp_rf                       pvth0=-1.1241356e-15+dpvthp_rf
+ k1=0.5203763              lk1=1.8548040e-08         wk1=1.1998529e-07
+ pk1=-1.7383759e-14        k2=4.1939260e-02+dk2p_rf  lk2=-6.6254260e-09+dlk2p_rf
+ wk2=-4.4246340e-08        pk2=7.4846270e-15         k3=0.00
+ dvt0=0.00                 dvt1=0.00                 dvt2=0.00
+ dvt0w=0.00                dvt1w=0.00                dvt2w=0.00
+ nlx=0.00                  w0=0.00                   k3b=0.00
+ vsat=1.3081252e05+dvsatp_rf                         wvsat=0+dwvsatp_rf
+ lvsat=-3.6562710e-04      ua=9.3578630e-10          lua=-1.7598350e-16
+ wua=-6.2823680e-16        pua=1.5976873e-22         ub=5.0912570e-19
+ lub=1.3507784e-25         wub=3.0629255e-25         pub=-1.3085017e-31
+ uc=-1.5731644e-10         luc=1.9437196e-17         wuc=1.4561782e-17
+ puc=-9.3561970e-24        rdsw=5.3000000e02         prwb=0.00
+ prwg=0.00                 wr=1.0000000              u0=9.7957610e-03+du0p_rf
+ lu0=-1.2475933e-10+dlu0p_rf                         wu0=-2.5725782e-09+dwu0p_rf
+ pu0=2.5785697e-16+dpu0p_rf                          a0=1.2640158
+ la0=5.3236360e-09         wa0=-4.0712480e-07        pa0=1.0862038e-13
+ keta=1.4996022e-02        lketa=-5.8725920e-10      wketa=8.7244130e-09
+ pketa=-2.4325694e-15      a1=0.00                   a2=0.4000000
+ ags=1.9847063e-02         lags=6.8821010e-11        wags=1.5278273e-09
+ pags=-6.8752220e-16       b0=0.00                   b1=0.00
+ voff=-0.1308021+dvoffp_rf lvoff=1.6353495e-10+dlvoffp_rf
+ wvoff=5.3724310e-09+dwvoffp_rf                      pvoff=-1.9905158e-15+dpvoffp_rf
+ nfactor=1.0000000+dnfactorp_rf                      pnfactor=0+dpnfactorp_rf
+ wnfactor=0+dwnfactorp_rf  lnfactor=0+dlnfactorp_rf  cit=-6.0918400e-05
+ lcit=1.1752459e-10        wcit=2.0354016e-10        pcit=-7.9076310e-17
+ cdsc=0.00                 cdscb=0.00                cdscd=-8.2898130e-05
+ lcdscd=3.7304140e-11      wcdscd=1.6464351e-11      pcdscd=-7.4089540e-18
+ eta0=-4.6875020e-04+deta0p_rf                       peta0=0+dpeta0p_rf
+ weta0=0+dweta0p_rf        leta0=2.5593752e-10+dleta0p_rf
+ etab=1.1323938e-03        letab=-5.5457720e-10      wetab=-5.4801690e-10
+ petab=2.4660761e-16       dsub=0.00                 pclm=0.9107697
+ lpclm=4.0153610e-08       wpclm=-5.4322380e-09      ppclm=2.4445072e-15
+ pdiblc1=1.0000000e-06     pdiblc2=7.9878660e-03     lpdiblc2=9.0546000e-10
+ wpdiblc2=-1.9097854e-10   ppdiblc2=8.5940170e-17    pdiblcb=1.0000000e-02
+ drout=0.00                pscbe1=3.5000000e08       pscbe2=5.0000000e-07
+ pvag=0.00                 delta=1.0000000e-02       alpha0=0.00
+ alpha1=6.8730453846       beta0=22.67827            kt1=-0.2367561
+ lkt1=-2.4825255e-09       wkt1=1.8848993e-08        pkt1=-1.8229216e-15
+ kt2=-2.5532207e-02        lkt2=-1.0989117e-10       wkt2=6.6289560e-09
+ pkt2=-1.2254391e-15       at=1.0000000e04           ute=-0.7199521
+ lute=6.2052350e-10        wute=1.0915658e-07        pute=9.7984170e-15
+ ua1=1.2240000e-09         ub1=-1.3554493e-18        lub1=2.6058948e-26
+ wub1=-2.2890885e-25       pub1=2.7781507e-32        uc1=7.0516520e-11
+ luc1=-7.6589150e-18       wuc1=-3.5766990e-17       puc1=8.1134340e-24
+ kt1l=0.00 prt=0 cj=0
+ mj=0.4476 pb=0.895226 cjsw=0
+ mjsw=0.3683619 pbsw=0.895226 cjswg=0
+ mjswg=0.3683619 pbswg=0.895226 tpb=1.572025e-03
+ tpbsw=1.572025e-03 tcj=9.739001e-04 tcjsw=4.130718e-04
+ js=4.92e-06 jsw=9.00e-10 nj=1.0
+ xti=3.0 cgdo=1.748e-10 cgso=1.748e-10
+ cgbo=1.0e-13 capmod=3 nqsmod=0
+ elm=0 xpart=0 cf=0
+ tlev=1 tlevc=1
+ wwc=-0.015 dlc=4.063e-8 dwc=-3.2e-8
+ noff=1.515 lnoff=1e-7 acde=0.9
+ moin=10 voffcv=-0.06 lvoffcv=1.0e-8
+ cgsl=2.62e-10 cgdl=2.62e-10 wcf=3.0e-17
+ noimod=2 noia=9.5e+18 noib=1.0e5
+ noic=1.4e-12 em=3.0e+07 ef=1.064
+ minr=1e-60 imax=0.01 imelt=0.01
//  )

//  *************************************************************
//                     1.8V MODEL OF P+/NW DIODE                *
//  *************************************************************
//  ******* field edge diode *******
     }
model pdio_rf_f diode level=1 tlevc=1 cj=0.001121 * cjp_rf mj=0.4476 pb=0.895226 cjsw=cjswp_rf
+ mjsw=0.3683619 vjsw=0.895226 cta=0.0009739001 ctp=0.0004130718 pta=0.001572025
+ ptp=0.001572025
//  **** gate edge diode *********
model pdio_rf_g diode level=1 tlevc=1 cj=cjp_rf mj=0.4476 pb=0.895226 cjsw=cjswgp_rf mjsw=0.3683619
+ vjsw=0.895226 cta=0.0009739001 ctp=0.0004130718 pta=0.001572025 ptp=0.001572025

ends pmos_rf

subckt pmos_rf_nw ( d g s b )
parameters lr=18.e-08 nr=64 wr=1.5e-6 lspace=0.54u ledge=2.6u ledgeeff=0.97u lsti=1.84u
+ wsti=3.37u rod=545 rsti=1198 ns=int(nr / 2 + 1) nd=int((nr + 1) / 2) lod=nr *
+ (lr + lspace) + 2 * ledge - lspace rb=(rod * lod / 12 + rsti * lsti / 2) * (rod
+ * wr / 12 + rsti * wsti / 2) / (lod * (rod * lod / 12 + rsti * lsti / 2) + wr
+ * (rod * wr / 12 + rsti * wsti / 2)) rdb=rod * lr / (wr * nr * 2)
//  ****************************
rg ( g gi ) resistor r=(1.098 * wr / nr / lr - 22.52 / nr / (lr * 1e6) + 100.15
+ / nr + 1190.3 * lr / nr / wr + 2.82)
rs ( s si ) resistor r=(0.0325 * (lr * 1e6 + 0.54) * (2 * ns + 1 / ns - 3) + 8.666
+ / ns + 0.4485) / (wr * 1e6)
rd ( d di ) resistor r=0.005417 * (lr * 1e6 + 0.54) * (nd + 2 / nd) + 0.0929 * (wr
+ * 1e6 + 2.94) / nd + 1.625 / (1.43 + (nd - 1) * (lr * 1e6 + 0.54))
//  *******************
cgs_m ( gi si ) capacitor c=(1.649 * nr * (lr * 1e6 + 0.54) / (0.1 * wr * 1e6 +
+ 4) + 0.158 * wr * 1e6 + 0.737) * 1e-15
cgd_m ( gi di ) capacitor c=(0.181 * nr * lr * 1e6 + 0.153 * nr + 0.331) * 1e-15
cds_m ( si di ) capacitor c=(0.0713 + 0.0842 * nr * wr * 1e6 / (lr * 1e6 + 0.9)
+ + 1.051 * nr * (lr * 1e6 + 0.54) / (wr * 1e6 + 9.8)) * 1e-15
//  *** Diodes  ****************
dss ( si sb ) pdio_rf_f area=(ns - 2) * wr * lspace + 2 * wr * ledgeeff + (nr -
+ int(nr / 2) * 2) * wr * (lspace - ledgeeff) pj=(ns - 2) * lspace * 2 + 2 * (2
+ * ledgeeff + wr) + (nr - int(nr / 2) * 2) * (2 * (lspace - ledgeeff) - wr)
ddd ( di db ) pdio_rf_f area=int(nr / 2) * wr * lspace + (nr - int(nr / 2) * 2)
+ * wr * ledgeeff pj=int(nr / 2) * lspace * 2 + (nr - int(nr / 2) * 2) * (2 * ledgeeff
+ + wr)
dsg ( si sb ) pdio_rf_g area=1e-15 pj=wr * nr
ddg ( di db ) pdio_rf_g area=1e-15 pj=wr * nr
//  ***************************************************************************
rb ( b bi ) resistor r=rb
cb ( b bi ) capacitor c=45.3f / rb
rdb ( db bi ) resistor r=rdb
cdb ( db bi ) capacitor c=45.3f / rdb
rsb ( sb bi ) resistor r=rdb
csb ( sb bi ) capacitor c=45.3f / rdb
//  ***** MOSFET *******
m0 ( di gi si bi ) pch_rf l=lr w=wr m=nr ad=0 as=0 pd=0 ps=0

model pch_rf bsim3v3  {
     1: type=p
+ lmin=1.8e-007             lmax=5.001e-07            wmin=1.5000e-06
+ wmax=8.001e-06            tnom=25.0                 version=3.24
+ tox=toxp_rf               toxm=4.08e-09             xj=1.7000001e-07
+ nch=3.9000000e17          lln=-1                    lwn=1.0000000
+ wln=1.0000000             wwn=-1.0000000            lint=1.4999999e-08
+ ll=0.00                   lw=0.00                   lwl=0.00
+ wint=5.0000000e-09        wl=0.00                   ww=0.00
+ wwl=0.00                  mobmod=1                  binunit=2
+ xl=-0.02e-6+dxlp_rf       xw=0.0+dxwp_rf            dwg=0.00
+ dwb=0.00                  ldif=9.00e-08             hdif=hdifp_rf
+ rsh=rshp_rf               rd=0                      rs=0
+ vth0=-0.4492160+dvthp_rf  lvth0=-8.1280260e-09+dlvthp_rf
+ wvth0=9.1421640e-09+dwvthp_rf                       pvth0=-1.1241356e-15+dpvthp_rf
+ k1=0.5203763              lk1=1.8548040e-08         wk1=1.1998529e-07
+ pk1=-1.7383759e-14        k2=4.1939260e-02+dk2p_rf  lk2=-6.6254260e-09+dlk2p_rf
+ wk2=-4.4246340e-08        pk2=7.4846270e-15         k3=0.00
+ dvt0=0.00                 dvt1=0.00                 dvt2=0.00
+ dvt0w=0.00                dvt1w=0.00                dvt2w=0.00
+ nlx=0.00                  w0=0.00                   k3b=0.00
+ vsat=1.3081252e05+dvsatp_rf                         wvsat=0+dwvsatp_rf
+ lvsat=-3.6562710e-04      ua=9.3578630e-10          lua=-1.7598350e-16
+ wua=-6.2823680e-16        pua=1.5976873e-22         ub=5.0912570e-19
+ lub=1.3507784e-25         wub=3.0629255e-25         pub=-1.3085017e-31
+ uc=-1.5731644e-10         luc=1.9437196e-17         wuc=1.4561782e-17
+ puc=-9.3561970e-24        rdsw=5.3000000e02         prwb=0.00
+ prwg=0.00                 wr=1.0000000              u0=9.7957610e-03+du0p_rf
+ lu0=-1.2475933e-10+dlu0p_rf                         wu0=-2.5725782e-09+dwu0p_rf
+ pu0=2.5785697e-16+dpu0p_rf                          a0=1.2640158
+ la0=5.3236360e-09         wa0=-4.0712480e-07        pa0=1.0862038e-13
+ keta=1.4996022e-02        lketa=-5.8725920e-10      wketa=8.7244130e-09
+ pketa=-2.4325694e-15      a1=0.00                   a2=0.4000000
+ ags=1.9847063e-02         lags=6.8821010e-11        wags=1.5278273e-09
+ pags=-6.8752220e-16       b0=0.00                   b1=0.00
+ voff=-0.1308021+dvoffp_rf lvoff=1.6353495e-10+dlvoffp_rf
+ wvoff=5.3724310e-09+dwvoffp_rf                      pvoff=-1.9905158e-15+dpvoffp_rf
+ nfactor=1.0000000+dnfactorp_rf                      pnfactor=0+dpnfactorp_rf
+ wnfactor=0+dwnfactorp_rf  lnfactor=0+dlnfactorp_rf  cit=-6.0918400e-05
+ lcit=1.1752459e-10        wcit=2.0354016e-10        pcit=-7.9076310e-17
+ cdsc=0.00                 cdscb=0.00                cdscd=-8.2898130e-05
+ lcdscd=3.7304140e-11      wcdscd=1.6464351e-11      pcdscd=-7.4089540e-18
+ eta0=-4.6875020e-04+deta0p_rf                       peta0=0+dpeta0p_rf
+ weta0=0+dweta0p_rf        leta0=2.5593752e-10+dleta0p_rf
+ etab=1.1323938e-03        letab=-5.5457720e-10      wetab=-5.4801690e-10
+ petab=2.4660761e-16       dsub=0.00                 pclm=0.9107697
+ lpclm=4.0153610e-08       wpclm=-5.4322380e-09      ppclm=2.4445072e-15
+ pdiblc1=1.0000000e-06     pdiblc2=7.9878660e-03     lpdiblc2=9.0546000e-10
+ wpdiblc2=-1.9097854e-10   ppdiblc2=8.5940170e-17    pdiblcb=1.0000000e-02
+ drout=0.00                pscbe1=3.5000000e08       pscbe2=5.0000000e-07
+ pvag=0.00                 delta=1.0000000e-02       alpha0=0.00
+ alpha1=6.8730453846       beta0=22.67827            kt1=-0.2367561
+ lkt1=-2.4825255e-09       wkt1=1.8848993e-08        pkt1=-1.8229216e-15
+ kt2=-2.5532207e-02        lkt2=-1.0989117e-10       wkt2=6.6289560e-09
+ pkt2=-1.2254391e-15       at=1.0000000e04           ute=-0.7199521
+ lute=6.2052350e-10        wute=1.0915658e-07        pute=9.7984170e-15
+ ua1=1.2240000e-09         ub1=-1.3554493e-18        lub1=2.6058948e-26
+ wub1=-2.2890885e-25       pub1=2.7781507e-32        uc1=7.0516520e-11
+ luc1=-7.6589150e-18       wuc1=-3.5766990e-17       puc1=8.1134340e-24
+ kt1l=0.00 prt=0 cj=0
+ mj=0.4476 pb=0.895226 cjsw=0
+ mjsw=0.3683619 pbsw=0.895226 cjswg=0
+ mjswg=0.3683619 pbswg=0.895226 tpb=1.572025e-03
+ tpbsw=1.572025e-03 tcj=9.739001e-04 tcjsw=4.130718e-04
+ js=4.92e-06 jsw=9.00e-10 nj=1.0
+ xti=3.0 cgdo=1.748e-10 cgso=1.748e-10
+ cgbo=1.0e-13 capmod=3 nqsmod=0
+ elm=0 xpart=0 cf=0
+ tlev=1 tlevc=1
+ wwc=-0.015 dlc=4.063e-8 dwc=-3.2e-8
+ noff=1.515 lnoff=1e-7 acde=0.9
+ moin=10 voffcv=-0.06 lvoffcv=1.0e-8
+ cgsl=2.62e-10 cgdl=2.62e-10 wcf=3.0e-17
+ noimod=2 noia=9.5e+18 noib=1.0e5
+ noic=1.4e-12 em=3.0e+07 ef=1.064
+ minr=1e-60 imax=0.01 imelt=0.01
//  )

//  *************************************************************
//                     1.8V MODEL OF P+/NW DIODE                *
//  *************************************************************
//  ******* field edge diode *******
     }
model pdio_rf_f diode level=1 tlevc=1 cj=0.001121 * cjp_rf mj=0.4476 pb=0.895226 cjsw=cjswp_rf
+ mjsw=0.3683619 vjsw=0.895226 cta=0.0009739001 ctp=0.0004130718 pta=0.001572025
+ ptp=0.001572025
//  **** gate edge diode *********
model pdio_rf_g diode level=1 tlevc=1 cj=cjp_rf mj=0.4476 pb=0.895226 cjsw=cjswgp_rf mjsw=0.3683619
+ vjsw=0.895226 cta=0.0009739001 ctp=0.0004130718 pta=0.001572025 ptp=0.001572025

ends pmos_rf_nw

subckt nmos_rf_mis ( d g s b )
parameters lr=18.e-08 nr=64 wr=1.5e-6 lspace=0.54u ledge=2.6u ledgeeff=0.97u lsti=1.84u
+ wsti=3.37u rod=2570 rsti=4597 ns=int(nr / 2 + 1) nd=int((nr + 1) / 2) lod=nr *
+ (lr + lspace) + 2 * ledge - lspace rb=(rod * lod / 12 + rsti * lsti / 2) * (rod
+ * wr / 12 + rsti * wsti / 2) / (lod * (rod * lod / 12 + rsti * lsti / 2) + wr
+ * (rod * wr / 12 + rsti * wsti / 2)) rdb=rod * lr / (wr * nr * 2) lef=lr - 20e-9
+ wef=wr geo_fac=1 / sqrt(nr * lef * wef * 1e12) vthmis=3.635e-3 * geo_fac * vthnmis_rf
+ dlmis=4.58e-3 * geo_fac * lef * dlnmis_rf dwmis=3.73e-3 * geo_fac * wef * dwnmis_rf
+ toxmis=1.01e-3 * geo_fac * toxn_rf * toxnmis_rf
//  ********************
//  ****************************

rg ( g gi ) resistor r=(0.539 * wr / nr / lr + 0.146 / nr / (lr * 1e6) + 17.86 /
+ nr + 584.9 * lr / nr / wr + 3.48)
rs ( s si ) resistor r=(0.0325 * (lr * 1e6 + 0.54) * (2 * ns + 1 / ns - 3) + 8.666
+ / ns + 0.4485) / (wr * 1e6)
rd ( d di ) resistor r=0.005417 * (lr * 1e6 + 0.54) * (nd + 2 / nd) + 0.0929 * (wr
+ * 1e6 + 2.94) / nd + 1.625 / (1.43 + (nd - 1) * (lr * 1e6 + 0.54))
//  *******************
cgs_m ( gi si ) capacitor c=(1.649 * nr * (lr * 1e6 + 0.54) / (0.1 * wr * 1e6 +
+ 4) + 0.158 * wr * 1e6 + 0.737) * 1e-15
cgd_m ( gi di ) capacitor c=(0.181 * nr * lr * 1e6 + 0.153 * nr + 0.331) * 1e-15
cds_m ( si di ) capacitor c=(0.0713 + 0.0842 * nr * wr * 1e6 / (lr * 1e6 + 0.9)
+ + 1.051 * nr * (lr * 1e6 + 0.54) / (wr * 1e6 + 9.8)) * 1e-15
//  *** Diodes  ****************
dss ( sb si ) ndio_rf_f area=(ns - 2) * wr * lspace + 2 * wr * ledgeeff + (nr -
+ int(nr / 2) * 2) * wr * (lspace - ledgeeff) pj=(ns - 2) * lspace * 2 + 2 * (2
+ * ledgeeff + wr) + (nr - int(nr / 2) * 2) * (2 * (lspace - ledgeeff) - wr)
ddd ( db di ) ndio_rf_f area=int(nr / 2) * wr * lspace + (nr - int(nr / 2) * 2)
+ * wr * ledgeeff pj=int(nr / 2) * lspace * 2 + (nr - int(nr / 2) * 2) * (2 * ledgeeff
+ + wr)
dsg ( sb si ) ndio_rf_g area=1e-15 pj=wr * nr
ddg ( db di ) ndio_rf_g area=1e-15 pj=wr * nr
//  ***************************************************************************
rb ( b bi ) resistor r=rb
cb ( b bi ) capacitor c=159f / rb
rdb ( db bi ) resistor r=rdb
cdb ( db bi ) capacitor c=159f / rdb
rsb ( sb bi ) resistor r=rdb
csb ( sb bi ) capacitor c=159f / rdb
//  ***** MOSFET *******
m0 ( di gi si bi ) nch_rf l=lr w=wr m=nr ad=0 as=0 pd=0 ps=0

model nch_rf bsim3v3  {
 1: type=n
+ lmin=1.8e-007 lmax=5.001e-07 wmin=1.5000e-06
+ wmax=8.001e-06 tnom=25.0 version=3.24
+ tox=toxn_rf + toxmis toxm=4.08e-09 xj=1.6000000e-07
+ nch=3.9000000e17 lln=-1 lwn=1.0000000
+ wln=1.0000000 wwn=-1 lint=1.0000000e-08
+ ll=0.00 lw=0.00 lwl=0.00
+ wint=3.0000000e-09 wl=0.00 ww=0.00
+ wwl=0.00 mobmod=1 binunit=2
+ xl= - 0.02e-6 + dxln_rf + dlmis xw=0.0 + dxwn_rf + dwmis
+ dwg=0.00 dwb=0.00
+ ldif=9.00e-08 hdif=hdifn_rf rsh=rshn_rf
+ rd=0 rs=0
+ vth0=0.4751966 + dvthn_rf + vthmis
+ lvth0=5.3743360e-09 + dlvthn_rf
+ wvth0=3.4482360e-10 + dwvthn_rf
+ pvth0=4.5089380e-15 + dpvthn_rf k1=dk1n_rf + 0.4007356
+ lk1=4.9634880e-08 wk1=8.8686750e-08 pk1=-6.3891820e-15
+ k2=6.3188600e-02 + dk2n_rf
+ lk2= - 2.3847164e-08 + dlk2n_rf wk2=-3.8768180e-08
+ pk2=5.0552590e-15 k3=0.00 dvt0=0.00
+ dvt1=0.00 dvt2=0.00 dvt0w=0.00
+ dvt1w=0.00 dvt2w=0.00 nlx=0.00
+ w0=0.00 k3b=0.00
+ vsat=8.4294280e04 + dvsatn_rf lvsat=-2.0140363e-04
+ wvsat=1.4459029e-03 + dwvsatn_rf pvsat=1.5350395e-12
+ ua=-9.0172960e-10 lua=3.5887640e-18 wua=4.2784730e-16
+ pua=-4.6390690e-23 ub=2.7527719e-18 lub=5.9103390e-27
+ wub=-9.4519130e-25 pub=-3.5064990e-33 uc=1.2291169e-10
+ luc=4.3605990e-18 wuc=-6.1268420e-17 puc=-2.2654354e-24
+ rdsw=drdswn_rf + 1.7000000e02 prwb=0.00
+ prwg=0.00 wr=1.0000000
+ u0=du0n_rf + 4.3840840e-02
+ lu0=1.2758692e-09 + dlu0n_rf
+ wu0= - 4.8608560e-09 + dwu0n_rf
+ pu0= - 2.4055863e-16 + dpu0n_rf a0=0.5262308
+ la0=8.2795080e-08 wa0=1.4537927e-07 pa0=-7.3379640e-14
+ keta=-4.4118840e-02 lketa=3.2284670e-09 wketa=2.2941933e-08
+ pketa=-2.7027957e-15 a1=0.00 a2=0.9900000
+ ags=-2.7693154e-02 lags=1.0727657e-09 wags=7.7723050e-08
+ pags=-1.0838496e-14 b0=0.00 b1=0.00
+ voff= - 0.1247105 + dvoffn_rf
+ lvoff= - 1.4487617e-09 + dlvoffn_rf
+ wvoff=1.6054964e-09 + dwvoffn_rf
+ pvoff= - 9.7541500e-16 + dpvoffn_rf
+ nfactor=1.0000000 + dnfactorn_rf
+ pnfactor=0 + dpnfactorn_rf
+ wnfactor=0 + dwnfactorn_rf
+ lnfactor=0 + dlnfactorn_rf cit=2.7498236e-04
+ lcit=1.0350804e-10 wcit=-3.0914837e-11 pcit=1.4220811e-17
+ cdsc=0.00 cdscb=0.00 cdscd=0.00
+ eta0= - 2.9405078e-04 + deta0n_rf
+ leta0=1.8126334e-10 + dleta0n_rf
+ weta0=3.0046217e-12 + dweta0n_rf
+ peta0= - 1.3821218e-18 + dpeta0n_rf etab=1.3878694e-03
+ letab=-6.8441990e-10 wetab=-3.6866540e-12 petab=1.6959704e-18
+ dsub=0.00 pclm=1.1010191 lpclm=3.8489530e-08
+ wpclm=6.6560680e-08 ppclm=4.0427110e-14 pdiblc1=1.0000000e-06
+ pdiblc2=-6.1190130e-03 lpdiblc2=5.0530930e-09 wpdiblc2=1.8349379e-09
+ ppdiblc2=-2.2121929e-16 pdiblcb=1.0000000e-02 drout=0.00
+ pscbe1=4.0000000e08 pscbe2=1.0000000e-06 pvag=0.00
+ delta=1.0000000e-02 alpha0=0.0 alpha1=0.448150714
+ beta0=11.59263 kt1=-0.2269240 lkt1=5.0937890e-09
+ wkt1=-2.2583577e-09 pkt1=-1.7512235e-15 kt2=-2.9338669e-02
+ lkt2=5.9558730e-10 wkt2=-1.9897783e-09 pkt2=7.3825670e-17
+ at=2.0000000e04 ute=-2.1610963 lute=8.2097990e-08
+ wute=7.8818350e-07 pute=-1.1786150e-13 ua1=1.2174792e-09
+ lua1=9.1298580e-19 wua1=7.7858620e-18 pua1=-1.0901051e-24
+ ub1=-3.8124500e-18 lub1=4.2482470e-25 wub1=2.8560549e-24
+ pub1=-4.2389140e-31 uc1=-1.5406690e-10 luc1=3.2328220e-17
+ wuc1=1.5903152e-16 puc1=-2.7204607e-23 kt1l=0.00
+ prt=0 cj=0 mj=0.3595262
+ pb=0.6882682 cjsw=0 mjsw=0.2003879
+ pbsw=0.6882682 cjswg=0 mjswg=0.43879
+ pbswg=0.6882682 tpb=1.554306e-03 tpbsw=1.554306e-03
+ tcj=1.040287e-03 tcjsw=6.45489e-04 js=8.38e-06
+ jsw=1.60e-11 nj=1.0 xti=3.0
+ cgdo=1.92e-10 cgso=1.92e-10 cgbo=1.0e-13
+ capmod=3 nqsmod=0 elm=0
+ xpart=0 cf=0 tlev=1
+ tlevc=1 wwc=-0.0225
+ dlc=2.68e-8 dwc=-2.833e-8 noff=2
+ lnoff=5e-8 acde=1 moin=10
+ voffcv=-0.05 lvoffcv=1.114e-8 cgsl=1.31e-10
+ cgdl=1.31e-10 wcf=2.82e-18 noimod=2
+ noia=2.0e+19 noib=1.2e4 noic=2.5e-13
+ em=3.0e+07 ef=0.874
+ minr=1e-60 imax=0.01 imelt=0.01
//  )

//  *************************************************************
//                     1.8V MODEL OF N+/PW DIODE                *
//  *************************************************************
     }

model ndio_rf_f diode level=1 tlevc=1 cj=cjn_rf mj=0.3595262 pb=0.6882682 cjsw=cjswn_rf
+ mjsw=0.2003879 vjsw=0.6882682 cta=0.001040287 ctp=0.000645489 pta=0.001554306 ptp=0.001554306

model ndio_rf_g diode level=1 tlevc=1 cj=cjn_rf mj=0.3595262 pb=0.6882682 cjsw=cjswgn_rf
+ mjsw=0.43879 vjsw=0.6882682 cta=0.001040287 ctp=0.000645489 pta=0.001554306 ptp=0.001554306

ends nmos_rf_mis

subckt pmos_rf_mis ( d g s b )
parameters lr=18.e-08 nr=64 wr=1.5e-6 lspace=0.54u ledge=2.6u ledgeeff=0.97u lsti=1.84u
+ wsti=3.37u rod=410 rsti=524 ns=int(nr / 2 + 1) nd=int((nr + 1) / 2) lod=nr * (lr
+ + lspace) + 2 * ledge - lspace rb=(rod * lod / 12 + rsti * lsti / 2) * (rod *
+ wr / 12 + rsti * wsti / 2) / (lod * (rod * lod / 12 + rsti * lsti / 2) + wr *
+ (rod * wr / 12 + rsti * wsti / 2)) rdb=rod * lr / (wr * nr * 2) lef=lr - 20e-9
+ wef=wr geo_fac=1 / sqrt(nr * lef * wef * 1e12) vthmis=4.432e-3 * geo_fac * vthpmis_rf
+ dlmis=3.96e-3 * geo_fac * lef * dlpmis_rf dwmis=3.26e-3 * geo_fac * wef * dwpmis_rf
+ toxmis=8.73e-4 * geo_fac * toxp_rf * toxpmis_rf
//  ********************
//  ****************************
rg ( g gi ) resistor r=(1.098 * wr / nr / lr - 22.52 / nr / (lr * 1e6) + 100.15
+ / nr + 1190.3 * lr / nr / wr + 2.82)
rs ( s si ) resistor r=(0.0325 * (lr * 1e6 + 0.54) * (2 * ns + 1 / ns - 3) + 8.666
+ / ns + 0.4485) / (wr * 1e6)
rd ( d di ) resistor r=0.005417 * (lr * 1e6 + 0.54) * (nd + 2 / nd) + 0.0929 * (wr
+ * 1e6 + 2.94) / nd + 1.625 / (1.43 + (nd - 1) * (lr * 1e6 + 0.54))
//  *******************
cgs_m ( gi si ) capacitor c=(1.649 * nr * (lr * 1e6 + 0.54) / (0.1 * wr * 1e6 +
+ 4) + 0.158 * wr * 1e6 + 0.737) * 1e-15
cgd_m ( gi di ) capacitor c=(0.181 * nr * lr * 1e6 + 0.153 * nr + 0.331) * 1e-15
cds_m ( si di ) capacitor c=(0.0713 + 0.0842 * nr * wr * 1e6 / (lr * 1e6 + 0.9)
+ + 1.051 * nr * (lr * 1e6 + 0.54) / (wr * 1e6 + 9.8)) * 1e-15
//  *** Diodes  ****************
dss ( si sb ) pdio_rf_f area=(ns - 2) * wr * lspace + 2 * wr * ledgeeff + (nr -
+ int(nr / 2) * 2) * wr * (lspace - ledgeeff) pj=(ns - 2) * lspace * 2 + 2 * (2
+ * ledgeeff + wr) + (nr - int(nr / 2) * 2) * (2 * (lspace - ledgeeff) - wr)
ddd ( di db ) pdio_rf_f area=int(nr / 2) * wr * lspace + (nr - int(nr / 2) * 2)
+ * wr * ledgeeff pj=int(nr / 2) * lspace * 2 + (nr - int(nr / 2) * 2) * (2 * ledgeeff
+ + wr)
dsg ( si sb ) pdio_rf_g area=1e-15 pj=wr * nr
ddg ( di db ) pdio_rf_g area=1e-15 pj=wr * nr
//  ***************************************************************************
rb ( b bi ) resistor r=rb
cb ( b bi ) capacitor c=21.6f / rb
rdb ( db bi ) resistor r=rdb
cdb ( db bi ) capacitor c=21.6f / rdb
rsb ( sb bi ) resistor r=rdb
csb ( sb bi ) capacitor c=21.6f / rdb
//  ***** MOSFET *******
m0 ( di gi si bi ) pch_rf l=lr w=wr m=nr ad=0 as=0 pd=0 ps=0

model pch_rf bsim3v3  {
 1: type=p
+ lmin=1.8e-007 lmax=5.001e-07 wmin=1.5000e-06
+ wmax=8.001e-06 tnom=25.0 version=3.24
+ tox=toxp_rf + toxmis toxm=4.08e-09 xj=1.7000001e-07
+ nch=3.9000000e17 lln=-1 lwn=1.0000000
+ wln=1.0000000 wwn=-1.0000000 lint=1.4999999e-08
+ ll=0.00 lw=0.00 lwl=0.00
+ wint=5.0000000e-09 wl=0.00 ww=0.00
+ wwl=0.00 mobmod=1 binunit=2
+ xl= - 0.02e-6 + dxlp_rf + dlmis xw=0.0 + dxwp_rf + dwmis
+ dwg=0.00 dwb=0.00
+ ldif=9.00e-08 hdif=hdifp_rf rsh=rshp_rf
+ rd=0 rs=0
+ vth0= - 0.4492160 + dvthp_rf + vthmis
+ lvth0= - 8.1280260e-09 + dlvthp_rf
+ wvth0=9.1421640e-09 + dwvthp_rf
+ pvth0= - 1.1241356e-15 + dpvthp_rf k1=0.5203763
+ lk1=1.8548040e-08 wk1=1.1998529e-07 pk1=-1.7383759e-14
+ k2=4.1939260e-02 + dk2p_rf
+ lk2= - 6.6254260e-09 + dlk2p_rf wk2=-4.4246340e-08
+ pk2=7.4846270e-15 k3=0.00 dvt0=0.00
+ dvt1=0.00 dvt2=0.00 dvt0w=0.00
+ dvt1w=0.00 dvt2w=0.00 nlx=0.00
+ w0=0.00 k3b=0.00
+ vsat=1.3081252e05 + dvsatp_rf wvsat=0 + dwvsatp_rf
+ lvsat=-3.6562710e-04 ua=9.3578630e-10 lua=-1.7598350e-16
+ wua=-6.2823680e-16 pua=1.5976873e-22 ub=5.0912570e-19
+ lub=1.3507784e-25 wub=3.0629255e-25 pub=-1.3085017e-31
+ uc=-1.5731644e-10 luc=1.9437196e-17 wuc=1.4561782e-17
+ puc=-9.3561970e-24 rdsw=5.3000000e02 prwb=0.00
+ prwg=0.00 wr=1.0000000
+ u0=9.7957610e-03 + du0p_rf
+ lu0= - 1.2475933e-10 + dlu0p_rf
+ wu0= - 2.5725782e-09 + dwu0p_rf
+ pu0=2.5785697e-16 + dpu0p_rf a0=1.2640158
+ la0=5.3236360e-09 wa0=-4.0712480e-07 pa0=1.0862038e-13
+ keta=1.4996022e-02 lketa=-5.8725920e-10 wketa=8.7244130e-09
+ pketa=-2.4325694e-15 a1=0.00 a2=0.4000000
+ ags=1.9847063e-02 lags=6.8821010e-11 wags=1.5278273e-09
+ pags=-6.8752220e-16 b0=0.00 b1=0.00
+ voff= - 0.1308021 + dvoffp_rf
+ lvoff=1.6353495e-10 + dlvoffp_rf
+ wvoff=5.3724310e-09 + dwvoffp_rf
+ pvoff= - 1.9905158e-15 + dpvoffp_rf
+ nfactor=1.0000000 + dnfactorp_rf
+ pnfactor=0 + dpnfactorp_rf
+ wnfactor=0 + dwnfactorp_rf
+ lnfactor=0 + dlnfactorp_rf cit=-6.0918400e-05
+ lcit=1.1752459e-10 wcit=2.0354016e-10 pcit=-7.9076310e-17
+ cdsc=0.00 cdscb=0.00 cdscd=-8.2898130e-05
+ lcdscd=3.7304140e-11 wcdscd=1.6464351e-11 pcdscd=-7.4089540e-18
+ eta0= - 4.6875020e-04 + deta0p_rf peta0=0 + dpeta0p_rf
+ weta0=0 + dweta0p_rf leta0=2.5593752e-10 + dleta0p_rf
+ etab=1.1323938e-03 letab=-5.5457720e-10 wetab=-5.4801690e-10
+ petab=2.4660761e-16 dsub=0.00 pclm=0.9107697
+ lpclm=4.0153610e-08 wpclm=-5.4322380e-09 ppclm=2.4445072e-15
+ pdiblc1=1.0000000e-06 pdiblc2=7.9878660e-03 lpdiblc2=9.0546000e-10
+ wpdiblc2=-1.9097854e-10 ppdiblc2=8.5940170e-17 pdiblcb=1.0000000e-02
+ drout=0.00 pscbe1=3.5000000e08 pscbe2=5.0000000e-07
+ pvag=0.00 delta=1.0000000e-02 alpha0=0.00
+ alpha1=6.8730453846 beta0=22.67827 kt1=-0.2367561
+ lkt1=-2.4825255e-09 wkt1=1.8848993e-08 pkt1=-1.8229216e-15
+ kt2=-2.5532207e-02 lkt2=-1.0989117e-10 wkt2=6.6289560e-09
+ pkt2=-1.2254391e-15 at=1.0000000e04 ute=-0.7199521
+ lute=6.2052350e-10 wute=1.0915658e-07 pute=9.7984170e-15
+ ua1=1.2240000e-09 ub1=-1.3554493e-18 lub1=2.6058948e-26
+ wub1=-2.2890885e-25 pub1=2.7781507e-32 uc1=7.0516520e-11
+ luc1=-7.6589150e-18 wuc1=-3.5766990e-17 puc1=8.1134340e-24
+ kt1l=0.00 prt=0 cj=0
+ mj=0.4476 pb=0.895226 cjsw=0
+ mjsw=0.3683619 pbsw=0.895226 cjswg=0
+ mjswg=0.3683619 pbswg=0.895226 tpb=1.572025e-03
+ tpbsw=1.572025e-03 tcj=9.739001e-04 tcjsw=4.130718e-04
+ js=4.92e-06 jsw=9.00e-10 nj=1.0
+ xti=3.0 cgdo=1.748e-10 cgso=1.748e-10
+ cgbo=1.0e-13 capmod=3 nqsmod=0
+ elm=0 xpart=0 cf=0
+ tlev=1 tlevc=1
+ wwc=-0.015 dlc=4.063e-8 dwc=-3.2e-8
+ noff=1.515 lnoff=1e-7 acde=0.9
+ moin=10 voffcv=-0.06 lvoffcv=1.0e-8
+ cgsl=2.62e-10 cgdl=2.62e-10 wcf=3.0e-17
+ noimod=2 noia=9.5e+18 noib=1.0e5
+ noic=1.4e-12 em=3.0e+07 ef=1.064
+ minr=1e-60 imax=0.01 imelt=0.01
//  )

//  *************************************************************
//                     1.8V MODEL OF P+/NW DIODE                *
//  *************************************************************
//  ******* field edge diode *******
     }
model pdio_rf_f diode level=1 tlevc=1 cj=0.001121 * cjp_rf mj=0.4476 pb=0.895226 cjsw=cjswp_rf
+ mjsw=0.3683619 vjsw=0.895226 cta=0.0009739001 ctp=0.0004130718 pta=0.001572025
+ ptp=0.001572025
//  **** gate edge diode *********
model pdio_rf_g diode level=1 tlevc=1 cj=cjp_rf mj=0.4476 pb=0.895226 cjsw=cjswgp_rf mjsw=0.3683619
+ vjsw=0.895226 cta=0.0009739001 ctp=0.0004130718 pta=0.001572025 ptp=0.001572025

ends pmos_rf_mis

subckt pmos_rf_nw_mis ( d g s b )
parameters lr=18.e-08 nr=64 wr=1.5e-6 lspace=0.54u ledge=2.6u ledgeeff=0.97u lsti=1.84u
+ wsti=3.37u rod=545 rsti=1198 ns=int(nr / 2 + 1) nd=int((nr + 1) / 2) lod=nr *
+ (lr + lspace) + 2 * ledge - lspace rb=(rod * lod / 12 + rsti * lsti / 2) * (rod
+ * wr / 12 + rsti * wsti / 2) / (lod * (rod * lod / 12 + rsti * lsti / 2) + wr
+ * (rod * wr / 12 + rsti * wsti / 2)) rdb=rod * lr / (wr * nr * 2) lef=lr - 20e-9
+ wef=wr geo_fac=1 / sqrt(nr * lef * wef * 1e12) vthmis=4.432e-3 * geo_fac * vthpmis_rf
+ dlmis=3.96e-3 * geo_fac * lef * dlpmis_rf dwmis=3.26e-3 * geo_fac * wef * dwpmis_rf
+ toxmis=8.73e-4 * geo_fac * toxp_rf * toxpmis_rf
//  ********************
//  ****************************
rg ( g gi ) resistor r=(1.098 * wr / nr / lr - 22.52 / nr / (lr * 1e6) + 100.15
+ / nr + 1190.3 * lr / nr / wr + 2.82)
rs ( s si ) resistor r=(0.0325 * (lr * 1e6 + 0.54) * (2 * ns + 1 / ns - 3) + 8.666
+ / ns + 0.4485) / (wr * 1e6)
rd ( d di ) resistor r=0.005417 * (lr * 1e6 + 0.54) * (nd + 2 / nd) + 0.0929 * (wr
+ * 1e6 + 2.94) / nd + 1.625 / (1.43 + (nd - 1) * (lr * 1e6 + 0.54))
//  *******************
cgs_m ( gi si ) capacitor c=(1.649 * nr * (lr * 1e6 + 0.54) / (0.1 * wr * 1e6 +
+ 4) + 0.158 * wr * 1e6 + 0.737) * 1e-15
cgd_m ( gi di ) capacitor c=(0.181 * nr * lr * 1e6 + 0.153 * nr + 0.331) * 1e-15
cds_m ( si di ) capacitor c=(0.0713 + 0.0842 * nr * wr * 1e6 / (lr * 1e6 + 0.9)
+ + 1.051 * nr * (lr * 1e6 + 0.54) / (wr * 1e6 + 9.8)) * 1e-15
//  *** Diodes  ****************
dss ( si sb ) pdio_rf_f area=(ns - 2) * wr * lspace + 2 * wr * ledgeeff + (nr -
+ int(nr / 2) * 2) * wr * (lspace - ledgeeff) pj=(ns - 2) * lspace * 2 + 2 * (2
+ * ledgeeff + wr) + (nr - int(nr / 2) * 2) * (2 * (lspace - ledgeeff) - wr)
ddd ( di db ) pdio_rf_f area=int(nr / 2) * wr * lspace + (nr - int(nr / 2) * 2)
+ * wr * ledgeeff pj=int(nr / 2) * lspace * 2 + (nr - int(nr / 2) * 2) * (2 * ledgeeff
+ + wr)
dsg ( si sb ) pdio_rf_g area=1e-15 pj=wr * nr
ddg ( di db ) pdio_rf_g area=1e-15 pj=wr * nr
//  ***************************************************************************
rb ( b bi ) resistor r=rb
cb ( b bi ) capacitor c=45.3f / rb
rdb ( db bi ) resistor r=rdb
cdb ( db bi ) capacitor c=45.3f / rdb
rsb ( sb bi ) resistor r=rdb
csb ( sb bi ) capacitor c=45.3f / rdb
//  ***** MOSFET *******
m0 ( di gi si bi ) pch_rf l=lr w=wr m=nr ad=0 as=0 pd=0 ps=0

model pch_rf bsim3v3  {
 1: type=p
+ lmin=1.8e-007 lmax=5.001e-07 wmin=1.5000e-06
+ wmax=8.001e-06 tnom=25.0 version=3.24
+ tox=toxp_rf + toxmis toxm=4.08e-09 xj=1.7000001e-07
+ nch=3.9000000e17 lln=-1 lwn=1.0000000
+ wln=1.0000000 wwn=-1.0000000 lint=1.4999999e-08
+ ll=0.00 lw=0.00 lwl=0.00
+ wint=5.0000000e-09 wl=0.00 ww=0.00
+ wwl=0.00 mobmod=1 binunit=2
+ xl= - 0.02e-6 + dxlp_rf + dlmis xw=0.0 + dxwp_rf + dwmis
+ dwg=0.00 dwb=0.00
+ ldif=9.00e-08 hdif=hdifp_rf rsh=rshp_rf
+ rd=0 rs=0
+ vth0= - 0.4492160 + dvthp_rf + vthmis
+ lvth0= - 8.1280260e-09 + dlvthp_rf
+ wvth0=9.1421640e-09 + dwvthp_rf
+ pvth0= - 1.1241356e-15 + dpvthp_rf k1=0.5203763
+ lk1=1.8548040e-08 wk1=1.1998529e-07 pk1=-1.7383759e-14
+ k2=4.1939260e-02 + dk2p_rf
+ lk2= - 6.6254260e-09 + dlk2p_rf wk2=-4.4246340e-08
+ pk2=7.4846270e-15 k3=0.00 dvt0=0.00
+ dvt1=0.00 dvt2=0.00 dvt0w=0.00
+ dvt1w=0.00 dvt2w=0.00 nlx=0.00
+ w0=0.00 k3b=0.00
+ vsat=1.3081252e05 + dvsatp_rf wvsat=0 + dwvsatp_rf
+ lvsat=-3.6562710e-04 ua=9.3578630e-10 lua=-1.7598350e-16
+ wua=-6.2823680e-16 pua=1.5976873e-22 ub=5.0912570e-19
+ lub=1.3507784e-25 wub=3.0629255e-25 pub=-1.3085017e-31
+ uc=-1.5731644e-10 luc=1.9437196e-17 wuc=1.4561782e-17
+ puc=-9.3561970e-24 rdsw=5.3000000e02 prwb=0.00
+ prwg=0.00 wr=1.0000000
+ u0=9.7957610e-03 + du0p_rf
+ lu0= - 1.2475933e-10 + dlu0p_rf
+ wu0= - 2.5725782e-09 + dwu0p_rf
+ pu0=2.5785697e-16 + dpu0p_rf a0=1.2640158
+ la0=5.3236360e-09 wa0=-4.0712480e-07 pa0=1.0862038e-13
+ keta=1.4996022e-02 lketa=-5.8725920e-10 wketa=8.7244130e-09
+ pketa=-2.4325694e-15 a1=0.00 a2=0.4000000
+ ags=1.9847063e-02 lags=6.8821010e-11 wags=1.5278273e-09
+ pags=-6.8752220e-16 b0=0.00 b1=0.00
+ voff= - 0.1308021 + dvoffp_rf
+ lvoff=1.6353495e-10 + dlvoffp_rf
+ wvoff=5.3724310e-09 + dwvoffp_rf
+ pvoff= - 1.9905158e-15 + dpvoffp_rf
+ nfactor=1.0000000 + dnfactorp_rf
+ pnfactor=0 + dpnfactorp_rf
+ wnfactor=0 + dwnfactorp_rf
+ lnfactor=0 + dlnfactorp_rf cit=-6.0918400e-05
+ lcit=1.1752459e-10 wcit=2.0354016e-10 pcit=-7.9076310e-17
+ cdsc=0.00 cdscb=0.00 cdscd=-8.2898130e-05
+ lcdscd=3.7304140e-11 wcdscd=1.6464351e-11 pcdscd=-7.4089540e-18
+ eta0= - 4.6875020e-04 + deta0p_rf peta0=0 + dpeta0p_rf
+ weta0=0 + dweta0p_rf leta0=2.5593752e-10 + dleta0p_rf
+ etab=1.1323938e-03 letab=-5.5457720e-10 wetab=-5.4801690e-10
+ petab=2.4660761e-16 dsub=0.00 pclm=0.9107697
+ lpclm=4.0153610e-08 wpclm=-5.4322380e-09 ppclm=2.4445072e-15
+ pdiblc1=1.0000000e-06 pdiblc2=7.9878660e-03 lpdiblc2=9.0546000e-10
+ wpdiblc2=-1.9097854e-10 ppdiblc2=8.5940170e-17 pdiblcb=1.0000000e-02
+ drout=0.00 pscbe1=3.5000000e08 pscbe2=5.0000000e-07
+ pvag=0.00 delta=1.0000000e-02 alpha0=0.00
+ alpha1=6.8730453846 beta0=22.67827 kt1=-0.2367561
+ lkt1=-2.4825255e-09 wkt1=1.8848993e-08 pkt1=-1.8229216e-15
+ kt2=-2.5532207e-02 lkt2=-1.0989117e-10 wkt2=6.6289560e-09
+ pkt2=-1.2254391e-15 at=1.0000000e04 ute=-0.7199521
+ lute=6.2052350e-10 wute=1.0915658e-07 pute=9.7984170e-15
+ ua1=1.2240000e-09 ub1=-1.3554493e-18 lub1=2.6058948e-26
+ wub1=-2.2890885e-25 pub1=2.7781507e-32 uc1=7.0516520e-11
+ luc1=-7.6589150e-18 wuc1=-3.5766990e-17 puc1=8.1134340e-24
+ kt1l=0.00 prt=0 cj=0
+ mj=0.4476 pb=0.895226 cjsw=0
+ mjsw=0.3683619 pbsw=0.895226 cjswg=0
+ mjswg=0.3683619 pbswg=0.895226 tpb=1.572025e-03
+ tpbsw=1.572025e-03 tcj=9.739001e-04 tcjsw=4.130718e-04
+ js=4.92e-06 jsw=9.00e-10 nj=1.0
+ xti=3.0 cgdo=1.748e-10 cgso=1.748e-10
+ cgbo=1.0e-13 capmod=3 nqsmod=0
+ elm=0 xpart=0 cf=0
+ tlev=1 tlevc=1
+ wwc=-0.015 dlc=4.063e-8 dwc=-3.2e-8
+ noff=1.515 lnoff=1e-7 acde=0.9
+ moin=10 voffcv=-0.06 lvoffcv=1.0e-8
+ cgsl=2.62e-10 cgdl=2.62e-10 wcf=3.0e-17
+ noimod=2 noia=9.5e+18 noib=1.0e5
+ noic=1.4e-12 em=3.0e+07 ef=1.064
+ minr=1e-60 imax=0.01 imelt=0.01
//  )

//  *************************************************************
//                     1.8V MODEL OF P+/NW DIODE                *
//  *************************************************************
//  ******* field edge diode *******
     }
model pdio_rf_f diode level=1 tlevc=1 cj=0.001121 * cjp_rf mj=0.4476 pb=0.895226 cjsw=cjswp_rf
+ mjsw=0.3683619 vjsw=0.895226 cta=0.0009739001 ctp=0.0004130718 pta=0.001572025
+ ptp=0.001572025
//  **** gate edge diode *********
model pdio_rf_g diode level=1 tlevc=1 cj=cjp_rf mj=0.4476 pb=0.895226 cjsw=cjswgp_rf mjsw=0.3683619
+ vjsw=0.895226 cta=0.0009739001 ctp=0.0004130718 pta=0.001572025 ptp=0.001572025

ends pmos_rf_nw_mis

endsection rf_mos
//  ************************************************************************************************
//
// 2) 3.3V MOS MODEL :
//
//
//               .lib MOS_RF33 : Typical model
//
//               Model name          NF               L (um)             Wf (um)
//                                low   high        low    high       low    high
//             -----------------------------------------------------------------
//
//               nmos_rf33        1     64         0.35   0.5          1.5    8
//    (normal nmos)
//             -----------------------------------------------------------------
//               pmos_rf33        1     64         0.3    0.5          1.5    8
//    (normal pmos with DNW)
//             -----------------------------------------------------------------
//
//               pmos_rf33_nw     1     64         0.3    0.5          1.5    8
//    (normal pmos without DNW)
//             -----------------------------------------------------------------
//               nmos_rf33_mis    1     64         0.35   0.5          1.5    8
//    (mismatch nmos)
//             -----------------------------------------------------------------
//               pmos_rf33_mis    1     64         0.3    0.5          1.5    8
//    (mismatch pmos with DNW)
//             -----------------------------------------------------------------
//
//               pmos_rf33_nw_mis 1     64         0.3    0.5          1.5    8
//    (mismatch pmos without DNW)
//             -----------------------------------------------------------------
//
//             **NF: Finger number
//
//
//
//  ************************************************************************************************
section rf_mos33

subckt nmos_rf33 ( d g s b )
parameters lr=35.e-08 nr=64 wr=1.5e-6 lspace=0.54u ledge=2.6u ledgeeff=0.97u lsti=1.84u
+ wsti=3.37u rod=2570 rsti=4597 ns=int(nr / 2 + 1) nd=int((nr + 1) / 2) lod=nr *
+ (lr + lspace) + 2 * ledge - lspace rb=(rod * lod / 12 + rsti * lsti / 2) * (rod
+ * wr / 12 + rsti * wsti / 2) / (lod * (rod * lod / 12 + rsti * lsti / 2) + wr
+ * (rod * wr / 12 + rsti * wsti / 2)) rdb=rod * lr / (wr * nr * 2)
//  ****************************
rg ( g gi ) resistor r=(37.018 / nr - 2.225e-7 / (nr * lr) + 151.212 * lr / (nr
+ * wr) - 0.275 * wr / (nr * lr) + 4.299)
rs ( s si ) resistor r=(0.0325 * (lr * 1e6 + 0.54) * (2 * ns + 1 / ns - 3) + 8.666
+ / ns + 0.4485) / (wr * 1e6)
rd ( d di ) resistor r=0.005417 * (lr * 1e6 + 0.54) * (nd + 2 / nd) + 0.0929 * (wr
+ * 1e6 + 2.94) / nd + 1.625 / (1.43 + (nd - 1) * (lr * 1e6 + 0.54))
//  *******************
cgs_m ( gi si ) capacitor c=(1.649 * nr * (lr * 1e6 + 0.54) / (0.1 * wr * 1e6 +
+ 4) + 0.158 * wr * 1e6 + 0.737) * 1e-15
cgd_m ( gi di ) capacitor c=(0.181 * nr * lr * 1e6 + 0.153 * nr + 0.331) * 1e-15
cds_m ( si di ) capacitor c=(0.0713 + 0.0842 * nr * wr * 1e6 / (lr * 1e6 + 0.9)
+ + 1.051 * nr * (lr * 1e6 + 0.54) / (wr * 1e6 + 9.8)) * 1e-15
//  *** Diodes  ****************
dss ( sb si ) ndio_rf33_f area=(ns - 2) * wr * lspace + 2 * wr * ledgeeff + (nr
+ - int(nr / 2) * 2) * wr * (lspace - ledgeeff) pj=(ns - 2) * lspace * 2 + 2 * (2
+ * ledgeeff + wr) + (nr - int(nr / 2) * 2) * (2 * (lspace - ledgeeff) - wr)
ddd ( db di ) ndio_rf33_f area=int(nr / 2) * wr * lspace + (nr - int(nr / 2) * 2)
+ * wr * ledgeeff pj=int(nr / 2) * lspace * 2 + (nr - int(nr / 2) * 2) * (2 * ledgeeff
+ + wr)
dsg ( sb si ) ndio_rf33_g area=1e-15 pj=wr * nr
ddg ( db di ) ndio_rf33_g area=1e-15 pj=wr * nr
//  ***************************************************************************
rb ( b bi ) resistor r=rb
cb ( b bi ) capacitor c=159f / rb
rdb ( db bi ) resistor r=rdb
cdb ( db bi ) capacitor c=159f / rdb
rsb ( sb bi ) resistor r=rdb
csb ( sb bi ) capacitor c=159f / rdb
//  ***** MOSFET *******
m0 ( di gi si bi ) nch_rf33 l=lr w=wr m=nr ad=0 as=0 pd=0 ps=0

model nch_rf33 bsim3v3  {
     1: type=n
+ lmin=3.5e-007             lmax=5.001e-07            wmin=1.5000e-06
+ wmax=8.001e-06            tnom=25.0                 version=3.24
+ tox=toxn_rf3              toxm=6.8e-09              xj=1.7000001e-07
+ nch=5.2600000e17          lln=-1                    lwn=1.0000000
+ wln=1.0000000             wwn=-1.0000000            lint=4.0000000e-08
+ ll=0.00                   lw=0.00                   lwl=0.00
+ wint=1.4999999e-08        wl=0.00                   ww=0.00
+ wwl=0.00                  mobmod=1                  binunit=2
+ xl=-0.02e-6+dxln_rf3      xw=0.0+dxwn_rf3           dwg=0.00
+ dwb=0.00                  ldif=9.00e-08             hdif=hdifn_rf3
+ rsh=rshn_rf3              rd=0                      rs=0
+ vth0=0.8659324+dvthn_rf3  lvth0=-1.6663769e-08+dlvthn_rf3
+ wvth0=-2.9767808e-09+dwvthn_rf3                     pvth0=3.8488080e-16+dpvthn_rf3
+ k1=0.7465155              lk1=1.0339250e-07         wk1=-8.4537670e-08
+ pk1=1.5833523e-14         k2=0.1900880+dk2n_rf3     lk2=-9.3703870e-08+dlk2n_rf3
+ wk2=4.6535320e-09         pk2=7.9773500e-15         k3=0.00
+ dvt0=0.00                 dvt1=0.00                 dvt2=0.00
+ dvt0w=0.00                dvt1w=0.00                dvt2w=0.00
+ nlx=0.00                  w0=0.00                   k3b=0.00
+ vsat=9.3130330e04+dvsatn_rf3                        lvsat=-8.5213050e-04
+ wvsat=-4.6598160e-03+dwvsatn_rf3                    pvsat=1.8639263e-09
+ ua=-6.7444880e-10         lua=-9.2429640e-17        wua=-9.2701740e-16
+ pua=3.6792740e-22         ub=2.1189834e-18          lub=2.1742727e-25
+ wub=5.1692720e-25         pub=-4.2773630e-31        uc=2.6250338e-10
+ luc=-3.8793870e-17        wuc=-1.1458971e-16        puc=2.7201846e-23
+ rdsw=5.4500000e02         prwb=0.00                 prwg=0.00
+ wr=1.0000000              u0=4.3624590e-02+du0n_rf3 lu0=3.8858720e-10+dlu0n_rf3
+ wu0=-9.7397600e-09+dwu0n_rf3                        pu0=2.5605882e-15+dpu0n_rf3
+ a0=0.8771189              la0=-7.1350570e-08        wa0=1.2410786e-07
+ pa0=-3.6596080e-14        keta=-5.3992410e-02       lketa=7.5446550e-09
+ wketa=-4.2032270e-08      pketa=1.8997448e-14       a1=0.00
+ a2=0.9900000              ags=-2.0000029e-02        b0=0.00
+ b1=0.00                   voff=-0.1004960+dvoffn_rf3
+ lvoff=-3.7645670e-09+dlvoffn_rf3                    wvoff=-4.5400990e-09+dwvoffn_rf3
+ pvoff=5.8367300e-15+dpvoffn_rf3                     nfactor=1.0000000+dnfactorn_rf3
+ pnfactor=0+dpnfactorn_rf3 wnfactor=0+dwnfactorn_rf3 lnfactor=0+dlnfactorn_rf3
+ cit=4.8816460e-04         lcit=6.6214410e-12        wcit=3.0312121e-11
+ pcit=-1.0693267e-17       cdsc=0.00                 cdscb=0.00
+ cdscd=0.00                eta0=-1.1666667e-03+deta0n_rf3
+ peta0=0+dpeta0n_rf3       weta0=0+dweta0n_rf3       leta0=6.6666660e-10+dleta0n_rf3
+ etab=3.7764110e-03        letab=-1.7105642e-09      wetab=-1.1034047e-09
+ petab=4.4136180e-16       dsub=0.00                 pclm=-0.2024819
+ lpclm=3.5845730e-07       wpclm=5.9620970e-07       ppclm=-1.3638029e-13
+ pdiblc1=1.0000000e-06     pdiblc2=-1.1344876e-02    lpdiblc2=4.9349870e-09
+ wpdiblc2=6.8173790e-09    ppdiblc2=-2.6974037e-15   pdiblcb=1.0000000e-02
+ drout=0.00                pscbe1=3.5000020e08       pscbe2=1.0000000e-06
+ pvag=0.00                 delta=1.0000000e-02       alpha0=0.0
+ alpha1=7.049416           beta0=21.5673             kt1=-0.2558013
+ lkt1=-1.7826350e-09       wkt1=-1.3100086e-07       pkt1=4.2649530e-14
+ kt2=-1.8057920e-02        lkt2=-1.6622183e-09       wkt2=1.0027706e-09
+ pkt2=-2.7101770e-15       at=2.0123486e04           lat=-4.9394840e-05
+ wat=-1.2311670e-03        pat=4.9246680e-10         ute=-1.0240370
+ lute=-9.5193410e-09       wute=1.8708050e-07        pute=-1.6398275e-13
+ ua1=2.0380289e-09         lua1=7.8843000e-19        wua1=1.9651618e-17
+ pua1=-7.8606470e-24       ub1=-1.5444776e-18        lub1=1.6075813e-25
+ wub1=-5.8817450e-25       pub1=-9.0092720e-32       uc1=1.0033722e-10
+ luc1=1.4186265e-17        wuc1=-9.6220470e-17       puc1=-8.2396960e-24
+ kt1l=0.00 prt=0 cj=0
+ mj=0.3259624 pb=0.7076023 cjsw=0
+ mjsw=0.1513672 pbsw=0.7076023 cjswg=0
+ mjswg=0.3513672 pbswg=0.7076023 tpb=1.687207e-03
+ tpbsw=1.687207e-03 tcj=9.923959e-04 tcjsw=5.019466e-04
+ js=7.93e-06 jsw=7.00e-11 nj=1.0
+ xti=3.0 cgdo=1.069e-10 cgso=1.069e-10
+ cgbo=1.0e-13 capmod=3 nqsmod=0
+ elm=0 xpart=0 cf=0
+ tlev=1 tlevc=1
+ wwc=0.0073 dlc=5.28e-8 dwc=-2.247e-8
+ noff=2.415 lnoff=3e-7 acde=0.825
+ moin=10 voffcv=-0.09 cgsl=3.71e-10
+ cgdl=3.71e-10 wcf=4.067e-17 noimod=2
+ noia=1.0e+20 noib=4.0e4 noic=-4.0e-13
+ em=3.0e+07 ef=0.881
+ minr=1e-60 imax=0.01 imelt=0.01
//  )
//  *************************************************************
//                       MODEL OF 3.3V N+/PW DIODE              *
//  *************************************************************
//
//  ****** diode field edge **************
     }
model ndio_rf33_f diode level=1 tlevc=1 cj=cjn_rf3 mj=0.3259624 pb=0.7076023 cjsw=cjswn_rf3
+ mjsw=0.1513672 vjsw=0.7076023 cta=0.0009923959 ctp=0.0005019466 pta=0.001687207
+ ptp=0.001687207
//  ******** diode gate edge ***************
model ndio_rf33_g diode level=1 tlevc=1 cj=cjn_rf3 mj=0.3259624 pb=0.7076023 cjsw=cjswgn_rf3
+ mjsw=0.3513672 vjsw=0.7076023 cta=0.0009923959 ctp=0.0005019466 pta=0.001687207
+ ptp=0.001687207

ends nmos_rf33

subckt pmos_rf33 ( d g s b )
parameters lr=35.e-08 nr=64 wr=1.5e-6 lspace=0.54u ledge=2.6u ledgeeff=0.97u lsti=1.84u
+ wsti=3.37u rod=410 rsti=524 ns=int(nr / 2 + 1) nd=int((nr + 1) / 2) lod=nr * (lr
+ + lspace) + 2 * ledge - lspace rb=(rod * lod / 12 + rsti * lsti / 2) * (rod *
+ wr / 12 + rsti * wsti / 2) / (lod * (rod * lod / 12 + rsti * lsti / 2) + wr *
+ (rod * wr / 12 + rsti * wsti / 2)) rdb=rod * lr / (wr * nr * 2)
//  ****************************
rg ( g gi ) resistor r=(122.29 / nr - 2.075e-5 / (nr * lr) + 158.61 * lr / (nr *
+ wr) - 0.434 * wr / (nr * lr) + 3.0955)
rs ( s si ) resistor r=(0.0325 * (lr * 1e6 + 0.54) * (2 * ns + 1 / ns - 3) + 8.666
+ / ns + 0.4485) / (wr * 1e6)
rd ( d di ) resistor r=0.005417 * (lr * 1e6 + 0.54) * (nd + 2 / nd) + 0.0929 * (wr
+ * 1e6 + 2.94) / nd + 1.625 / (1.43 + (nd - 1) * (lr * 1e6 + 0.54))
//  *******************
cgs_m ( gi si ) capacitor c=(1.649 * nr * (lr * 1e6 + 0.54) / (0.1 * wr * 1e6 +
+ 4) + 0.158 * wr * 1e6 + 0.737) * 1e-15
cgd_m ( gi di ) capacitor c=(0.181 * nr * lr * 1e6 + 0.153 * nr + 0.331) * 1e-15
cds_m ( si di ) capacitor c=(0.0713 + 0.0842 * nr * wr * 1e6 / (lr * 1e6 + 0.9)
+ + 1.051 * nr * (lr * 1e6 + 0.54) / (wr * 1e6 + 9.8)) * 1e-15
//  *** Diodes  ****************
dss ( si sb ) pdio_rf33_f area=(ns - 2) * wr * lspace + 2 * wr * ledgeeff + (nr
+ - int(nr / 2) * 2) * wr * (lspace - ledgeeff) pj=(ns - 2) * lspace * 2 + 2 * (2
+ * ledgeeff + wr) + (nr - int(nr / 2) * 2) * (2 * (lspace - ledgeeff) - wr)
ddd ( di db ) pdio_rf33_f area=int(nr / 2) * wr * lspace + (nr - int(nr / 2) * 2)
+ * wr * ledgeeff pj=int(nr / 2) * lspace * 2 + (nr - int(nr / 2) * 2) * (2 * ledgeeff
+ + wr)
dsg ( si sb ) pdio_rf33_g area=1e-15 pj=wr * nr
ddg ( di db ) pdio_rf33_g area=1e-15 pj=wr * nr
//  ***************************************************************************
rb ( b bi ) resistor r=rb
cb ( b bi ) capacitor c=21.6f / rb
rdb ( db bi ) resistor r=rdb
cdb ( db bi ) capacitor c=21.6f / rdb
rsb ( sb bi ) resistor r=rdb
csb ( sb bi ) capacitor c=21.6f / rdb
m0 ( di gi si bi ) pch_rf33 l=lr w=wr m=nr ad=0 as=0 pd=0 ps=0

model pch_rf33 bsim3v3  {
     1: type=p
+ lmin=3.0e-007             lmax=5.001e-07            wmin=1.5000e-06
+ wmax=8.001e-06            tnom=25.0                 version=3.24
+ tox=toxp_rf3              toxm=6.77e-09             xj=1.7000001e-07
+ nch=4.9500000e17          lln=-1                    lwn=1.0000000
+ wln=1.0000000             wwn=-1.0000000            lint=3.5000000e-08
+ ll=0.00                   lw=0.00                   lwl=0.00
+ wint=2.0000000e-08        wl=0.00                   ww=0.00
+ wwl=0.00                  mobmod=1                  binunit=2
+ xl=-0.02e-6+dxlp_rf3      xw=0.0+dxwp_rf3           dwg=0.00
+ dwb=0.00                  ldif=9.00e-08             hdif=hdifp_rf3
+ rsh=rshp_rf3              rd=0                      rs=0
+ vth0=-0.7727100+dvthp_rf3 lvth0=2.6472314e-08+dlvthp_rf3
+ wvth0=7.1924870e-08+dwvthp_rf3                      pvth0=-2.1035541e-14+dpvthp_rf3
+ k1=0.7699419              lk1=4.8013860e-08         wk1=-1.8243896e-09
+ pk1=-6.7361810e-15        k2=0.1315423+dk2p_rf3     lk2=-2.9673100e-08+dlk2p_rf3
+ wk2=-2.7064845e-08        pk2=1.1859575e-14         k3=0.00
+ dvt0=0.00                 dvt1=0.00                 dvt2=0.00
+ dvt0w=0.00                dvt1w=0.00                dvt2w=0.00
+ nlx=0.00                  w0=0.00                   k3b=0.00
+ vsat=1.1960348e05+dvsatp_rf3                        lvsat=-3.9374090e-03
+ wvsat=8.9667880e-03+dwvsatp_rf3                     pvsat=-3.6763830e-09
+ ua=1.1489469e-09          lua=-1.5785002e-16        wua=7.2362290e-16
+ pua=-1.8122008e-22        ub=2.4514955e-19          lub=2.2735166e-25
+ wub=-1.3483237e-24        pub=3.1242082e-31         uc=-7.1838280e-11
+ luc=2.2854683e-17         wuc=-1.7606797e-16        puc=3.7125090e-23
+ rdsw=9.0000000e02         prwb=0.00                 prwg=0.00
+ wr=1.0000000              u0=1.0090719e-02+du0p_rf3 lu0=-7.0264360e-11+dlu0p_rf3
+ wu0=-6.4404460e-10+dwu0p_rf3                        pu0=8.6706510e-17+dpu0p_rf3
+ a0=1.1409379              la0=-8.2552040e-08        wa0=1.4760643e-07
+ pa0=-4.3866910e-14        keta=-1.1318877e-02       lketa=1.9036506e-09
+ wketa=1.4257295e-08       pketa=-7.1586210e-15      a1=0.00
+ a2=0.9900000              ags=2.0000000e-02         b0=0.00
+ b1=0.00                   voff=-0.1250223+dvoffp_rf3
+ lvoff=8.9629090e-09+dlvoffp_rf3                     wvoff=-9.4300550e-10+dwvoffp_rf3
+ pvoff=-2.9157947e-15+dpvoffp_rf3                    nfactor=1.0000000+dnfactorp_rf3
+ pnfactor=0+dpnfactorp_rf3 wnfactor=0+dwnfactorp_rf3 lnfactor=0+dlnfactorp_rf3
+ cit=5.6188450e-04         lcit=-2.1553027e-11       wcit=-1.5986783e-10
+ pcit=5.1946790e-17        cdsc=0.00                 cdscb=0.00
+ cdscd=0.00                eta0=-2.8413706e-04+deta0p_rf3
+ leta0=1.5749620e-10+dleta0p_rf3                     weta0=-3.5866790e-10+dweta0p_rf3
+ peta0=1.4705383e-16+dpeta0p_rf3                     etab=8.7586620e-04
+ letab=-4.0010520e-10      wetab=-3.0878400e-10      petab=1.2660141e-16
+ dsub=0.00                 pclm=0.6645077            lpclm=6.3411240e-09
+ wpclm=4.0103030e-08       ppclm=2.9485615e-15       pdiblc1=1.0000000e-06
+ pdiblc2=-3.7510620e-03    lpdiblc2=1.9479358e-09    wpdiblc2=5.5112340e-09
+ ppdiblc2=-2.2596061e-15   pdiblcb=1.0000000e-02     drout=0.00
+ pscbe1=3.3079310e08       lpscbe1=7.8748250         wpscbe1=-17.9333440
+ ppscbe1=7.3526710e-06     pscbe2=5.0000000e-07      pvag=0.00
+ delta=1.0000000e-02       alpha0=0.00               alpha1=0.143217238
+ beta0=16.10832            kt1=-0.3349694            lkt1=1.3342398e-08
+ wkt1=1.7269201e-09        pkt1=2.6498244e-15        kt2=-3.0737475e-02
+ lkt2=8.9807820e-10        wkt2=7.7649210e-10        pkt2=6.7802250e-17
+ at=-5.0000000e04          ute=-0.1318164            lute=-2.0271844e-07
+ wute=-3.7188310e-07       pute=2.1910628e-13        ua1=3.6255330e-09
+ lua1=-6.5375860e-16       wua1=-1.8496589e-15       pua1=7.5836000e-22
+ ub1=-2.5613780e-18        lub1=2.0065643e-25        wub1=6.1348050e-25
+ pub1=-2.3489589e-31       uc1=4.8751200e-11         luc1=-1.0675619e-17
+ wuc1=4.7864960e-17        puc1=-1.9370043e-25       kt1l=0.00
+ prt=0 cj=1.03531e-06 mj=0.3954951
+ pb=0.8049122 cjsw=2.23115e-13 mjsw=0.2573111
+ pbsw=0.8049122 cjswg=2.345762e-13 mjswg=0.2573111
+ pbswg=0.8049122 tpb=1.625007e-03 tpbsw=1.625007e-03
+ tcj=9.940197e-04 tcjsw=6.908749e-04 js=3.10e-06
+ jsw=2.80e-11 nj=1.0 xti=3.0
+ cgdo=1.218e-10 cgso=1.218e-10 cgbo=1.0e-13
+ capmod=3 nqsmod=0 elm=0
+ xpart=0 cf=0 tlev=1
+ tlevc=1 wwc=0.0342
+ dlc=4.847e-8 dwc=-2.064e-8 noff=1.847
+ lnoff=1.5e-7 acde=1.258 moin=10
+ voffcv=-0.045 cgsl=3.44e-10 cgdl=3.44e-10
+ wcf=4.066e-17 noimod=2 noia=2.0e+19
+ noib=8.0e+3 noic=5.4e-12 em=3.0e+07
+ ef=1.094
+ minr=1e-60 imax=0.01 imelt=0.01
//  )
     }
//  *************************************************************
//                       MODEL OF 3.3V P+/NW DIODE              *
//  *************************************************************
//  ** field edge diode  *******
model pdio_rf33_f diode level=1 tlevc=1 cj=cjp_rf3 mj=0.3954951 pb=0.8049122 cjsw=cjswp_rf3
+ mjsw=0.2573111 vjsw=0.8049122 cta=0.0009940197 ctp=0.0006908749 pta=0.001625007
+ ptp=0.001625007
//  **** gate edge diode *********
model pdio_rf33_g diode level=1 tlevc=1 cj=cjp_rf3 mj=0.3954951 pb=0.8049122 cjsw=cjswgp_rf3
+ mjsw=0.2573111 vjsw=0.8049122 cta=0.0009940197 ctp=0.0006908749 pta=0.001625007
+ ptp=0.001625007
ends pmos_rf33

subckt pmos_rf33_nw ( d g s b )
parameters lr=35.e-08 nr=64 wr=1.5e-6 lspace=0.54u ledge=2.6u ledgeeff=0.97u lsti=1.84u
+ wsti=3.37u rod=545 rsti=1198 ns=int(nr / 2 + 1) nd=int((nr + 1) / 2) lod=nr *
+ (lr + lspace) + 2 * ledge - lspace rb=(rod * lod / 12 + rsti * lsti / 2) * (rod
+ * wr / 12 + rsti * wsti / 2) / (lod * (rod * lod / 12 + rsti * lsti / 2) + wr
+ * (rod * wr / 12 + rsti * wsti / 2)) rdb=rod * lr / (wr * nr * 2)
//  ****************************
rg ( g gi ) resistor r=(122.29 / nr - 2.075e-5 / (nr * lr) + 158.61 * lr / (nr *
+ wr) - 0.434 * wr / (nr * lr) + 3.0955)
rs ( s si ) resistor r=(0.0325 * (lr * 1e6 + 0.54) * (2 * ns + 1 / ns - 3) + 8.666
+ / ns + 0.4485) / (wr * 1e6)
rd ( d di ) resistor r=0.005417 * (lr * 1e6 + 0.54) * (nd + 2 / nd) + 0.0929 * (wr
+ * 1e6 + 2.94) / nd + 1.625 / (1.43 + (nd - 1) * (lr * 1e6 + 0.54))
//  *******************
cgs_m ( gi si ) capacitor c=(1.649 * nr * (lr * 1e6 + 0.54) / (0.1 * wr * 1e6 +
+ 4) + 0.158 * wr * 1e6 + 0.737) * 1e-15
cgd_m ( gi di ) capacitor c=(0.181 * nr * lr * 1e6 + 0.153 * nr + 0.331) * 1e-15
cds_m ( si di ) capacitor c=(0.0713 + 0.0842 * nr * wr * 1e6 / (lr * 1e6 + 0.9)
+ + 1.051 * nr * (lr * 1e6 + 0.54) / (wr * 1e6 + 9.8)) * 1e-15
//  *** Diodes  ****************
dss ( si sb ) pdio_rf33_f area=(ns - 2) * wr * lspace + 2 * wr * ledgeeff + (nr
+ - int(nr / 2) * 2) * wr * (lspace - ledgeeff) pj=(ns - 2) * lspace * 2 + 2 * (2
+ * ledgeeff + wr) + (nr - int(nr / 2) * 2) * (2 * (lspace - ledgeeff) - wr)
ddd ( di db ) pdio_rf33_f area=int(nr / 2) * wr * lspace + (nr - int(nr / 2) * 2)
+ * wr * ledgeeff pj=int(nr / 2) * lspace * 2 + (nr - int(nr / 2) * 2) * (2 * ledgeeff
+ + wr)
dsg ( si sb ) pdio_rf33_g area=1e-15 pj=wr * nr
ddg ( di db ) pdio_rf33_g area=1e-15 pj=wr * nr
//  ***************************************************************************
rb ( b bi ) resistor r=rb
cb ( b bi ) capacitor c=45.3f / rb
rdb ( db bi ) resistor r=rdb
cdb ( db bi ) capacitor c=45.3f / rdb
rsb ( sb bi ) resistor r=rdb
csb ( sb bi ) capacitor c=45.3f / rdb
m0 ( di gi si bi ) pch_rf33 l=lr w=wr m=nr ad=0 as=0 pd=0 ps=0

model pch_rf33 bsim3v3  {
     1: type=p
+ lmin=3.0e-007             lmax=5.001e-07            wmin=1.5000e-06
+ wmax=8.001e-06            tnom=25.0                 version=3.24
+ tox=toxp_rf3              toxm=6.77e-09             xj=1.7000001e-07
+ nch=4.9500000e17          lln=-1                    lwn=1.0000000
+ wln=1.0000000             wwn=-1.0000000            lint=3.5000000e-08
+ ll=0.00                   lw=0.00                   lwl=0.00
+ wint=2.0000000e-08        wl=0.00                   ww=0.00
+ wwl=0.00                  mobmod=1                  binunit=2
+ xl=-0.02e-6+dxlp_rf3      xw=0.0+dxwp_rf3           dwg=0.00
+ dwb=0.00                  ldif=9.00e-08             hdif=hdifp_rf3
+ rsh=rshp_rf3              rd=0                      rs=0
+ vth0=-0.7727100+dvthp_rf3 lvth0=2.6472314e-08+dlvthp_rf3
+ wvth0=7.1924870e-08+dwvthp_rf3                      pvth0=-2.1035541e-14+dpvthp_rf3
+ k1=0.7699419              lk1=4.8013860e-08         wk1=-1.8243896e-09
+ pk1=-6.7361810e-15        k2=0.1315423+dk2p_rf3     lk2=-2.9673100e-08+dlk2p_rf3
+ wk2=-2.7064845e-08        pk2=1.1859575e-14         k3=0.00
+ dvt0=0.00                 dvt1=0.00                 dvt2=0.00
+ dvt0w=0.00                dvt1w=0.00                dvt2w=0.00
+ nlx=0.00                  w0=0.00                   k3b=0.00
+ vsat=1.1960348e05+dvsatp_rf3                        lvsat=-3.9374090e-03
+ wvsat=8.9667880e-03+dwvsatp_rf3                     pvsat=-3.6763830e-09
+ ua=1.1489469e-09          lua=-1.5785002e-16        wua=7.2362290e-16
+ pua=-1.8122008e-22        ub=2.4514955e-19          lub=2.2735166e-25
+ wub=-1.3483237e-24        pub=3.1242082e-31         uc=-7.1838280e-11
+ luc=2.2854683e-17         wuc=-1.7606797e-16        puc=3.7125090e-23
+ rdsw=9.0000000e02         prwb=0.00                 prwg=0.00
+ wr=1.0000000              u0=1.0090719e-02+du0p_rf3 lu0=-7.0264360e-11+dlu0p_rf3
+ wu0=-6.4404460e-10+dwu0p_rf3                        pu0=8.6706510e-17+dpu0p_rf3
+ a0=1.1409379              la0=-8.2552040e-08        wa0=1.4760643e-07
+ pa0=-4.3866910e-14        keta=-1.1318877e-02       lketa=1.9036506e-09
+ wketa=1.4257295e-08       pketa=-7.1586210e-15      a1=0.00
+ a2=0.9900000              ags=2.0000000e-02         b0=0.00
+ b1=0.00                   voff=-0.1250223+dvoffp_rf3
+ lvoff=8.9629090e-09+dlvoffp_rf3                     wvoff=-9.4300550e-10+dwvoffp_rf3
+ pvoff=-2.9157947e-15+dpvoffp_rf3                    nfactor=1.0000000+dnfactorp_rf3
+ pnfactor=0+dpnfactorp_rf3 wnfactor=0+dwnfactorp_rf3 lnfactor=0+dlnfactorp_rf3
+ cit=5.6188450e-04         lcit=-2.1553027e-11       wcit=-1.5986783e-10
+ pcit=5.1946790e-17        cdsc=0.00                 cdscb=0.00
+ cdscd=0.00                eta0=-2.8413706e-04+deta0p_rf3
+ leta0=1.5749620e-10+dleta0p_rf3                     weta0=-3.5866790e-10+dweta0p_rf3
+ peta0=1.4705383e-16+dpeta0p_rf3                     etab=8.7586620e-04
+ letab=-4.0010520e-10      wetab=-3.0878400e-10      petab=1.2660141e-16
+ dsub=0.00                 pclm=0.6645077            lpclm=6.3411240e-09
+ wpclm=4.0103030e-08       ppclm=2.9485615e-15       pdiblc1=1.0000000e-06
+ pdiblc2=-3.7510620e-03    lpdiblc2=1.9479358e-09    wpdiblc2=5.5112340e-09
+ ppdiblc2=-2.2596061e-15   pdiblcb=1.0000000e-02     drout=0.00
+ pscbe1=3.3079310e08       lpscbe1=7.8748250         wpscbe1=-17.9333440
+ ppscbe1=7.3526710e-06     pscbe2=5.0000000e-07      pvag=0.00
+ delta=1.0000000e-02       alpha0=0.00               alpha1=0.143217238
+ beta0=16.10832            kt1=-0.3349694            lkt1=1.3342398e-08
+ wkt1=1.7269201e-09        pkt1=2.6498244e-15        kt2=-3.0737475e-02
+ lkt2=8.9807820e-10        wkt2=7.7649210e-10        pkt2=6.7802250e-17
+ at=-5.0000000e04          ute=-0.1318164            lute=-2.0271844e-07
+ wute=-3.7188310e-07       pute=2.1910628e-13        ua1=3.6255330e-09
+ lua1=-6.5375860e-16       wua1=-1.8496589e-15       pua1=7.5836000e-22
+ ub1=-2.5613780e-18        lub1=2.0065643e-25        wub1=6.1348050e-25
+ pub1=-2.3489589e-31       uc1=4.8751200e-11         luc1=-1.0675619e-17
+ wuc1=4.7864960e-17        puc1=-1.9370043e-25       kt1l=0.00
+ prt=0 cj=1.03531e-06 mj=0.3954951
+ pb=0.8049122 cjsw=2.23115e-13 mjsw=0.2573111
+ pbsw=0.8049122 cjswg=2.345762e-13 mjswg=0.2573111
+ pbswg=0.8049122 tpb=1.625007e-03 tpbsw=1.625007e-03
+ tcj=9.940197e-04 tcjsw=6.908749e-04 js=3.10e-06
+ jsw=2.80e-11 nj=1.0 xti=3.0
+ cgdo=1.218e-10 cgso=1.218e-10 cgbo=1.0e-13
+ capmod=3 nqsmod=0 elm=0
+ xpart=0 cf=0 tlev=1
+ tlevc=1 wwc=0.0342
+ dlc=4.847e-8 dwc=-2.064e-8 noff=1.847
+ lnoff=1.5e-7 acde=1.258 moin=10
+ voffcv=-0.045 cgsl=3.44e-10 cgdl=3.44e-10
+ wcf=4.066e-17 noimod=2 noia=2.0e+19
+ noib=8.0e+3 noic=5.4e-12 em=3.0e+07
+ ef=1.094
+ minr=1e-60 imax=0.01 imelt=0.01
//  )
     }
//  *************************************************************
//                       MODEL OF 3.3V P+/NW DIODE              *
//  *************************************************************
//  ** field edge diode  *******
model pdio_rf33_f diode level=1 tlevc=1 cj=cjp_rf3 mj=0.3954951 pb=0.8049122 cjsw=cjswp_rf3
+ mjsw=0.2573111 vjsw=0.8049122 cta=0.0009940197 ctp=0.0006908749 pta=0.001625007
+ ptp=0.001625007
//  **** gate edge diode *********
model pdio_rf33_g diode level=1 tlevc=1 cj=cjp_rf3 mj=0.3954951 pb=0.8049122 cjsw=cjswgp_rf3
+ mjsw=0.2573111 vjsw=0.8049122 cta=0.0009940197 ctp=0.0006908749 pta=0.001625007
+ ptp=0.001625007
ends pmos_rf33_nw

subckt nmos_rf33_mis ( d g s b )
parameters lr=35.e-08 nr=64 wr=1.5e-6 lspace=0.54u ledge=2.6u ledgeeff=0.97u lsti=1.84u
+ wsti=3.37u rod=2570 rsti=4597 ns=int(nr / 2 + 1) nd=int((nr + 1) / 2) lod=nr *
+ (lr + lspace) + 2 * ledge - lspace rb=(rod * lod / 12 + rsti * lsti / 2) * (rod
+ * wr / 12 + rsti * wsti / 2) / (lod * (rod * lod / 12 + rsti * lsti / 2) + wr
+ * (rod * wr / 12 + rsti * wsti / 2)) rdb=rod * lr / (wr * nr * 2) lef=lr - 20e-9
+ wef=wr geo_fac=1 / sqrt(nr * lef * wef * 1e12) vthmis=6.227e-3 * geo_fac * vthnmis_rf3
+ dlmis=3.65e-3 * geo_fac * lef * dlnmis_rf3 dwmis=2.98e-3 * geo_fac * wef * dwnmis_rf3
+ toxmis=8.04e-4 * geo_fac * toxn_rf3 * toxnmis_rf3
//  ********************
//  ****************************
rg ( g gi ) resistor r=(37.018 / nr - 2.225e-7 / (nr * lr) + 151.212 * lr / (nr
+ * wr) - 0.275 * wr / (nr * lr) + 4.299)
rs ( s si ) resistor r=(0.0325 * (lr * 1e6 + 0.54) * (2 * ns + 1 / ns - 3) + 8.666
+ / ns + 0.4485) / (wr * 1e6)
rd ( d di ) resistor r=0.005417 * (lr * 1e6 + 0.54) * (nd + 2 / nd) + 0.0929 * (wr
+ * 1e6 + 2.94) / nd + 1.625 / (1.43 + (nd - 1) * (lr * 1e6 + 0.54))
//  *******************
cgs_m ( gi si ) capacitor c=(1.649 * nr * (lr * 1e6 + 0.54) / (0.1 * wr * 1e6 +
+ 4) + 0.158 * wr * 1e6 + 0.737) * 1e-15
cgd_m ( gi di ) capacitor c=(0.181 * nr * lr * 1e6 + 0.153 * nr + 0.331) * 1e-15
cds_m ( si di ) capacitor c=(0.0713 + 0.0842 * nr * wr * 1e6 / (lr * 1e6 + 0.9)
+ + 1.051 * nr * (lr * 1e6 + 0.54) / (wr * 1e6 + 9.8)) * 1e-15
//  *** Diodes  ****************
dss ( sb si ) ndio_rf33_f area=(ns - 2) * wr * lspace + 2 * wr * ledgeeff + (nr
+ - int(nr / 2) * 2) * wr * (lspace - ledgeeff) pj=(ns - 2) * lspace * 2 + 2 * (2
+ * ledgeeff + wr) + (nr - int(nr / 2) * 2) * (2 * (lspace - ledgeeff) - wr)
ddd ( db di ) ndio_rf33_f area=int(nr / 2) * wr * lspace + (nr - int(nr / 2) * 2)
+ * wr * ledgeeff pj=int(nr / 2) * lspace * 2 + (nr - int(nr / 2) * 2) * (2 * ledgeeff
+ + wr)
dsg ( sb si ) ndio_rf33_g area=1e-15 pj=wr * nr
ddg ( db di ) ndio_rf33_g area=1e-15 pj=wr * nr
//  ***************************************************************************
rb ( b bi ) resistor r=rb
cb ( b bi ) capacitor c=159f / rb
rdb ( db bi ) resistor r=rdb
cdb ( db bi ) capacitor c=159f / rdb
rsb ( sb bi ) resistor r=rdb
csb ( sb bi ) capacitor c=159f / rdb
//  ***** MOSFET *******
m0 ( di gi si bi ) nch_rf33 l=lr w=wr m=nr ad=0 as=0 pd=0 ps=0

model nch_rf33 bsim3v3  {
 1: type=n
+ lmin=3.5e-007 lmax=5.001e-07 wmin=1.5000e-06
+ wmax=8.001e-06 tnom=25.0 version=3.24
+ tox=toxn_rf3 + toxmis toxm=6.8e-09 xj=1.7000001e-07
+ nch=5.2600000e17 lln=-1 lwn=1.0000000
+ wln=1.0000000 wwn=-1.0000000 lint=4.0000000e-08
+ ll=0.00 lw=0.00 lwl=0.00
+ wint=1.4999999e-08 wl=0.00 ww=0.00
+ wwl=0.00 mobmod=1 binunit=2
+ xl= - 0.02e-6 + dxln_rf3 + dlmis xw=0.0 + dxwn_rf3 + dwmis
+ dwg=0.00 dwb=0.00
+ ldif=9.00e-08 hdif=hdifn_rf3 rsh=rshn_rf3
+ rd=0 rs=0
+ vth0=0.8659324 + dvthn_rf3 + vthmis
+ lvth0= - 1.6663769e-08 + dlvthn_rf3
+ wvth0= - 2.9767808e-09 + dwvthn_rf3
+ pvth0=3.8488080e-16 + dpvthn_rf3 k1=0.7465155
+ lk1=1.0339250e-07 wk1=-8.4537670e-08 pk1=1.5833523e-14
+ k2=0.1900880 + dk2n_rf3 lk2= - 9.3703870e-08 + dlk2n_rf3
+ wk2=4.6535320e-09 pk2=7.9773500e-15 k3=0.00
+ dvt0=0.00 dvt1=0.00 dvt2=0.00
+ dvt0w=0.00 dvt1w=0.00 dvt2w=0.00
+ nlx=0.00 w0=0.00 k3b=0.00
+ vsat=9.3130330e04 + dvsatn_rf3 lvsat=-8.5213050e-04
+ wvsat= - 4.6598160e-03 + dwvsatn_rf3 pvsat=1.8639263e-09
+ ua=-6.7444880e-10 lua=-9.2429640e-17 wua=-9.2701740e-16
+ pua=3.6792740e-22 ub=2.1189834e-18 lub=2.1742727e-25
+ wub=5.1692720e-25 pub=-4.2773630e-31 uc=2.6250338e-10
+ luc=-3.8793870e-17 wuc=-1.1458971e-16 puc=2.7201846e-23
+ rdsw=5.4500000e02 prwb=0.00 prwg=0.00
+ wr=1.0000000 u0=4.3624590e-02 + du0n_rf3
+ lu0=3.8858720e-10 + dlu0n_rf3
+ wu0= - 9.7397600e-09 + dwu0n_rf3
+ pu0=2.5605882e-15 + dpu0n_rf3 a0=0.8771189
+ la0=-7.1350570e-08 wa0=1.2410786e-07 pa0=-3.6596080e-14
+ keta=-5.3992410e-02 lketa=7.5446550e-09 wketa=-4.2032270e-08
+ pketa=1.8997448e-14 a1=0.00 a2=0.9900000
+ ags=-2.0000029e-02 b0=0.00 b1=0.00
+ voff= - 0.1004960 + dvoffn_rf3
+ lvoff= - 3.7645670e-09 + dlvoffn_rf3
+ wvoff= - 4.5400990e-09 + dwvoffn_rf3
+ pvoff=5.8367300e-15 + dpvoffn_rf3
+ nfactor=1.0000000 + dnfactorn_rf3
+ pnfactor=0 + dpnfactorn_rf3
+ wnfactor=0 + dwnfactorn_rf3
+ lnfactor=0 + dlnfactorn_rf3 cit=4.8816460e-04
+ lcit=6.6214410e-12 wcit=3.0312121e-11 pcit=-1.0693267e-17
+ cdsc=0.00 cdscb=0.00 cdscd=0.00
+ eta0= - 1.1666667e-03 + deta0n_rf3 peta0=0 + dpeta0n_rf3
+ weta0=0 + dweta0n_rf3 leta0=6.6666660e-10 + dleta0n_rf3
+ etab=3.7764110e-03 letab=-1.7105642e-09 wetab=-1.1034047e-09
+ petab=4.4136180e-16 dsub=0.00 pclm=-0.2024819
+ lpclm=3.5845730e-07 wpclm=5.9620970e-07 ppclm=-1.3638029e-13
+ pdiblc1=1.0000000e-06 pdiblc2=-1.1344876e-02 lpdiblc2=4.9349870e-09
+ wpdiblc2=6.8173790e-09 ppdiblc2=-2.6974037e-15 pdiblcb=1.0000000e-02
+ drout=0.00 pscbe1=3.5000020e08 pscbe2=1.0000000e-06
+ pvag=0.00 delta=1.0000000e-02 alpha0=0.0
+ alpha1=7.049416 beta0=21.5673 kt1=-0.2558013
+ lkt1=-1.7826350e-09 wkt1=-1.3100086e-07 pkt1=4.2649530e-14
+ kt2=-1.8057920e-02 lkt2=-1.6622183e-09 wkt2=1.0027706e-09
+ pkt2=-2.7101770e-15 at=2.0123486e04 lat=-4.9394840e-05
+ wat=-1.2311670e-03 pat=4.9246680e-10 ute=-1.0240370
+ lute=-9.5193410e-09 wute=1.8708050e-07 pute=-1.6398275e-13
+ ua1=2.0380289e-09 lua1=7.8843000e-19 wua1=1.9651618e-17
+ pua1=-7.8606470e-24 ub1=-1.5444776e-18 lub1=1.6075813e-25
+ wub1=-5.8817450e-25 pub1=-9.0092720e-32 uc1=1.0033722e-10
+ luc1=1.4186265e-17 wuc1=-9.6220470e-17 puc1=-8.2396960e-24
+ kt1l=0.00 prt=0 cj=0
+ mj=0.3259624 pb=0.7076023 cjsw=0
+ mjsw=0.1513672 pbsw=0.7076023 cjswg=0
+ mjswg=0.3513672 pbswg=0.7076023 tpb=1.687207e-03
+ tpbsw=1.687207e-03 tcj=9.923959e-04 tcjsw=5.019466e-04
+ js=7.93e-06 jsw=7.00e-11 nj=1.0
+ xti=3.0 cgdo=1.069e-10 cgso=1.069e-10
+ cgbo=1.0e-13 capmod=3 nqsmod=0
+ elm=0 xpart=0 cf=0
+ tlev=1 tlevc=1
+ wwc=0.0073 dlc=5.28e-8 dwc=-2.247e-8
+ noff=2.415 lnoff=3e-7 acde=0.825
+ moin=10 voffcv=-0.09 cgsl=3.71e-10
+ cgdl=3.71e-10 wcf=4.067e-17 noimod=2
+ noia=1.0e+20 noib=4.0e4 noic=-4.0e-13
+ em=3.0e+07 ef=0.881
+ minr=1e-60 imax=0.01 imelt=0.01
+ mvtwl=8.91e-9  mbewl=4.78e-9
//  )
//  *************************************************************
//                       MODEL OF 3.3V N+/PW DIODE              *
//  *************************************************************
//
//  ****** diode field edge **************
     }
model ndio_rf33_f diode level=1 tlevc=1 cj=cjn_rf3 mj=0.3259624 pb=0.7076023 cjsw=cjswn_rf3
+ mjsw=0.1513672 vjsw=0.7076023 cta=0.0009923959 ctp=0.0005019466 pta=0.001687207
+ ptp=0.001687207
//  ******** diode gate edge ***************
model ndio_rf33_g diode level=1 tlevc=1 cj=cjn_rf3 mj=0.3259624 pb=0.7076023 cjsw=cjswgn_rf3
+ mjsw=0.3513672 vjsw=0.7076023 cta=0.0009923959 ctp=0.0005019466 pta=0.001687207
+ ptp=0.001687207
//  ********************************
ends nmos_rf33_mis

subckt pmos_rf33_mis ( d g s b )
parameters lr=35.e-08 nr=64 wr=1.5e-6 lspace=0.54u ledge=2.6u ledgeeff=0.97u lsti=1.84u
+ wsti=3.37u rod=410 rsti=524 ns=int(nr / 2 + 1) nd=int((nr + 1) / 2) lod=nr * (lr
+ + lspace) + 2 * ledge - lspace rb=(rod * lod / 12 + rsti * lsti / 2) * (rod *
+ wr / 12 + rsti * wsti / 2) / (lod * (rod * lod / 12 + rsti * lsti / 2) + wr *
+ (rod * wr / 12 + rsti * wsti / 2)) rdb=rod * lr / (wr * nr * 2) lef=lr - 20e-9
+ wef=wr geo_fac=1 / sqrt(nr * lef * wef * 1e12) vthmis=4.525e-3 * geo_fac * vthpmis_rf3
+ dlmis=2.47e-3 * geo_fac * lef * dlpmis_rf3 dwmis=2.01e-3 * geo_fac * wef * dwpmis_rf3
+ toxmis=5.43e-4 * geo_fac * toxp_rf3 * toxpmis_rf3
//  ********************
//  ****************************
rg ( g gi ) resistor r=(122.29 / nr - 2.075e-5 / (nr * lr) + 158.61 * lr / (nr *
+ wr) - 0.434 * wr / (nr * lr) + 3.0955)
rs ( s si ) resistor r=(0.0325 * (lr * 1e6 + 0.54) * (2 * ns + 1 / ns - 3) + 8.666
+ / ns + 0.4485) / (wr * 1e6)
rd ( d di ) resistor r=0.005417 * (lr * 1e6 + 0.54) * (nd + 2 / nd) + 0.0929 * (wr
+ * 1e6 + 2.94) / nd + 1.625 / (1.43 + (nd - 1) * (lr * 1e6 + 0.54))
//  *******************
cgs_m ( gi si ) capacitor c=(1.649 * nr * (lr * 1e6 + 0.54) / (0.1 * wr * 1e6 +
+ 4) + 0.158 * wr * 1e6 + 0.737) * 1e-15
cgd_m ( gi di ) capacitor c=(0.181 * nr * lr * 1e6 + 0.153 * nr + 0.331) * 1e-15
cds_m ( si di ) capacitor c=(0.0713 + 0.0842 * nr * wr * 1e6 / (lr * 1e6 + 0.9)
+ + 1.051 * nr * (lr * 1e6 + 0.54) / (wr * 1e6 + 9.8)) * 1e-15
//  *** Diodes  ****************
dss ( si sb ) pdio_rf33_f area=(ns - 2) * wr * lspace + 2 * wr * ledgeeff + (nr
+ - int(nr / 2) * 2) * wr * (lspace - ledgeeff) pj=(ns - 2) * lspace * 2 + 2 * (2
+ * ledgeeff + wr) + (nr - int(nr / 2) * 2) * (2 * (lspace - ledgeeff) - wr)
ddd ( di db ) pdio_rf33_f area=int(nr / 2) * wr * lspace + (nr - int(nr / 2) * 2)
+ * wr * ledgeeff pj=int(nr / 2) * lspace * 2 + (nr - int(nr / 2) * 2) * (2 * ledgeeff
+ + wr)
dsg ( si sb ) pdio_rf33_g area=1e-15 pj=wr * nr
ddg ( di db ) pdio_rf33_g area=1e-15 pj=wr * nr
//  ***************************************************************************
rb ( b bi ) resistor r=rb
cb ( b bi ) capacitor c=21.6f / rb
rdb ( db bi ) resistor r=rdb
cdb ( db bi ) capacitor c=21.6f / rdb
rsb ( sb bi ) resistor r=rdb
csb ( sb bi ) capacitor c=21.6f / rdb
m0 ( di gi si bi ) pch_rf33 l=lr w=wr m=nr ad=0 as=0 pd=0 ps=0

model pch_rf33 bsim3v3  {
 1: type=p
+ lmin=3.0e-007 lmax=5.001e-07 wmin=1.5000e-06
+ wmax=8.001e-06 tnom=25.0 version=3.24
+ tox=toxp_rf3 + toxmis toxm=6.77e-09 xj=1.7000001e-07
+ nch=4.9500000e17 lln=-1 lwn=1.0000000
+ wln=1.0000000 wwn=-1.0000000 lint=3.5000000e-08
+ ll=0.00 lw=0.00 lwl=0.00
+ wint=2.0000000e-08 wl=0.00 ww=0.00
+ wwl=0.00 mobmod=1 binunit=2
+ xl= - 0.02e-6 + dxlp_rf3 + dlmis xw=0.0 + dxwp_rf3 + dwmis
+ dwg=0.00 dwb=0.00
+ ldif=9.00e-08 hdif=hdifp_rf3 rsh=rshp_rf3
+ rd=0 rs=0
+ vth0= - 0.7727100 + dvthp_rf3 + vthmis
+ lvth0=2.6472314e-08 + dlvthp_rf3
+ wvth0=7.1924870e-08 + dwvthp_rf3
+ pvth0= - 2.1035541e-14 + dpvthp_rf3 k1=0.7699419
+ lk1=4.8013860e-08 wk1=-1.8243896e-09 pk1=-6.7361810e-15
+ k2=0.1315423 + dk2p_rf3 lk2= - 2.9673100e-08 + dlk2p_rf3
+ wk2=-2.7064845e-08 pk2=1.1859575e-14 k3=0.00
+ dvt0=0.00 dvt1=0.00 dvt2=0.00
+ dvt0w=0.00 dvt1w=0.00 dvt2w=0.00
+ nlx=0.00 w0=0.00 k3b=0.00
+ vsat=1.1960348e05 + dvsatp_rf3 lvsat=-3.9374090e-03
+ wvsat=8.9667880e-03 + dwvsatp_rf3 pvsat=-3.6763830e-09
+ ua=1.1489469e-09 lua=-1.5785002e-16 wua=7.2362290e-16
+ pua=-1.8122008e-22 ub=2.4514955e-19 lub=2.2735166e-25
+ wub=-1.3483237e-24 pub=3.1242082e-31 uc=-7.1838280e-11
+ luc=2.2854683e-17 wuc=-1.7606797e-16 puc=3.7125090e-23
+ rdsw=9.0000000e02 prwb=0.00 prwg=0.00
+ wr=1.0000000 u0=1.0090719e-02 + du0p_rf3
+ lu0= - 7.0264360e-11 + dlu0p_rf3
+ wu0= - 6.4404460e-10 + dwu0p_rf3
+ pu0=8.6706510e-17 + dpu0p_rf3 a0=1.1409379
+ la0=-8.2552040e-08 wa0=1.4760643e-07 pa0=-4.3866910e-14
+ keta=-1.1318877e-02 lketa=1.9036506e-09 wketa=1.4257295e-08
+ pketa=-7.1586210e-15 a1=0.00 a2=0.9900000
+ ags=2.0000000e-02 b0=0.00 b1=0.00
+ voff= - 0.1250223 + dvoffp_rf3
+ lvoff=8.9629090e-09 + dlvoffp_rf3
+ wvoff= - 9.4300550e-10 + dwvoffp_rf3
+ pvoff= - 2.9157947e-15 + dpvoffp_rf3
+ nfactor=1.0000000 + dnfactorp_rf3
+ pnfactor=0 + dpnfactorp_rf3
+ wnfactor=0 + dwnfactorp_rf3
+ lnfactor=0 + dlnfactorp_rf3 cit=5.6188450e-04
+ lcit=-2.1553027e-11 wcit=-1.5986783e-10 pcit=5.1946790e-17
+ cdsc=0.00 cdscb=0.00 cdscd=0.00
+ eta0= - 2.8413706e-04 + deta0p_rf3
+ leta0=1.5749620e-10 + dleta0p_rf3
+ weta0= - 3.5866790e-10 + dweta0p_rf3
+ peta0=1.4705383e-16 + dpeta0p_rf3 etab=8.7586620e-04
+ letab=-4.0010520e-10 wetab=-3.0878400e-10 petab=1.2660141e-16
+ dsub=0.00 pclm=0.6645077 lpclm=6.3411240e-09
+ wpclm=4.0103030e-08 ppclm=2.9485615e-15 pdiblc1=1.0000000e-06
+ pdiblc2=-3.7510620e-03 lpdiblc2=1.9479358e-09 wpdiblc2=5.5112340e-09
+ ppdiblc2=-2.2596061e-15 pdiblcb=1.0000000e-02 drout=0.00
+ pscbe1=3.3079310e08 lpscbe1=7.8748250 wpscbe1=-17.9333440
+ ppscbe1=7.3526710e-06 pscbe2=5.0000000e-07 pvag=0.00
+ delta=1.0000000e-02 alpha0=0.00 alpha1=0.143217238
+ beta0=16.10832 kt1=-0.3349694 lkt1=1.3342398e-08
+ wkt1=1.7269201e-09 pkt1=2.6498244e-15 kt2=-3.0737475e-02
+ lkt2=8.9807820e-10 wkt2=7.7649210e-10 pkt2=6.7802250e-17
+ at=-5.0000000e04 ute=-0.1318164 lute=-2.0271844e-07
+ wute=-3.7188310e-07 pute=2.1910628e-13 ua1=3.6255330e-09
+ lua1=-6.5375860e-16 wua1=-1.8496589e-15 pua1=7.5836000e-22
+ ub1=-2.5613780e-18 lub1=2.0065643e-25 wub1=6.1348050e-25
+ pub1=-2.3489589e-31 uc1=4.8751200e-11 luc1=-1.0675619e-17
+ wuc1=4.7864960e-17 puc1=-1.9370043e-25 kt1l=0.00
+ prt=0 cj=1.03531e-06 mj=0.3954951
+ pb=0.8049122 cjsw=2.23115e-13 mjsw=0.2573111
+ pbsw=0.8049122 cjswg=2.345762e-13 mjswg=0.2573111
+ pbswg=0.8049122 tpb=1.625007e-03 tpbsw=1.625007e-03
+ tcj=9.940197e-04 tcjsw=6.908749e-04 js=3.10e-06
+ jsw=2.80e-11 nj=1.0 xti=3.0
+ cgdo=1.218e-10 cgso=1.218e-10 cgbo=1.0e-13
+ capmod=3 nqsmod=0 elm=0
+ xpart=0 cf=0 tlev=1
+ tlevc=1 wwc=0.0342
+ dlc=4.847e-8 dwc=-2.064e-8 noff=1.847
+ lnoff=1.5e-7 acde=1.258 moin=10
+ voffcv=-0.045 cgsl=3.44e-10 cgdl=3.44e-10
+ wcf=4.066e-17 noimod=2 noia=2.0e+19
+ noib=8.0e+3 noic=5.4e-12 em=3.0e+07
+ ef=1.094
+ minr=1e-60 imax=0.01 imelt=0.01
//  )
     }
//  *************************************************************
//                       MODEL OF 3.3V P+/NW DIODE              *
//  *************************************************************
//  ** field edge diode  *******
model pdio_rf33_f diode level=1 tlevc=1 cj=cjp_rf3 mj=0.3954951 pb=0.8049122 cjsw=cjswp_rf3
+ mjsw=0.2573111 vjsw=0.8049122 cta=0.0009940197 ctp=0.0006908749 pta=0.001625007
+ ptp=0.001625007
//  **** gate edge diode *********
model pdio_rf33_g diode level=1 tlevc=1 cj=cjp_rf3 mj=0.3954951 pb=0.8049122 cjsw=cjswgp_rf3
+ mjsw=0.2573111 vjsw=0.8049122 cta=0.0009940197 ctp=0.0006908749 pta=0.001625007
+ ptp=0.001625007
//  ********************************
ends pmos_rf33_mis

subckt pmos_rf33_nw_mis ( d g s b )
parameters lr=35.e-08 nr=64 wr=1.5e-6 lspace=0.54u ledge=2.6u ledgeeff=0.97u lsti=1.84u
+ wsti=3.37u rod=545 rsti=1198 ns=int(nr / 2 + 1) nd=int((nr + 1) / 2) lod=nr *
+ (lr + lspace) + 2 * ledge - lspace rb=(rod * lod / 12 + rsti * lsti / 2) * (rod
+ * wr / 12 + rsti * wsti / 2) / (lod * (rod * lod / 12 + rsti * lsti / 2) + wr
+ * (rod * wr / 12 + rsti * wsti / 2)) rdb=rod * lr / (wr * nr * 2) lef=lr - 20e-9
+ wef=wr geo_fac=1 / sqrt(nr * lef * wef * 1e12) vthmis=4.525e-3 * geo_fac * vthpmis_rf3
+ dlmis=2.47e-3 * geo_fac * lef * dlpmis_rf3 dwmis=2.01e-3 * geo_fac * wef * dwpmis_rf3
+ toxmis=5.43e-4 * geo_fac * toxp_rf3 * toxpmis_rf3
//  ********************
//  ****************************
rg ( g gi ) resistor r=(122.29 / nr - 2.075e-5 / (nr * lr) + 158.61 * lr / (nr *
+ wr) - 0.434 * wr / (nr * lr) + 3.0955)
rs ( s si ) resistor r=(0.0325 * (lr * 1e6 + 0.54) * (2 * ns + 1 / ns - 3) + 8.666
+ / ns + 0.4485) / (wr * 1e6)
rd ( d di ) resistor r=0.005417 * (lr * 1e6 + 0.54) * (nd + 2 / nd) + 0.0929 * (wr
+ * 1e6 + 2.94) / nd + 1.625 / (1.43 + (nd - 1) * (lr * 1e6 + 0.54))
//  *******************
cgs_m ( gi si ) capacitor c=(1.649 * nr * (lr * 1e6 + 0.54) / (0.1 * wr * 1e6 +
+ 4) + 0.158 * wr * 1e6 + 0.737) * 1e-15
cgd_m ( gi di ) capacitor c=(0.181 * nr * lr * 1e6 + 0.153 * nr + 0.331) * 1e-15
cds_m ( si di ) capacitor c=(0.0713 + 0.0842 * nr * wr * 1e6 / (lr * 1e6 + 0.9)
+ + 1.051 * nr * (lr * 1e6 + 0.54) / (wr * 1e6 + 9.8)) * 1e-15
//  *** Diodes  ****************
dss ( si sb ) pdio_rf33_f area=(ns - 2) * wr * lspace + 2 * wr * ledgeeff + (nr
+ - int(nr / 2) * 2) * wr * (lspace - ledgeeff) pj=(ns - 2) * lspace * 2 + 2 * (2
+ * ledgeeff + wr) + (nr - int(nr / 2) * 2) * (2 * (lspace - ledgeeff) - wr)
ddd ( di db ) pdio_rf33_f area=int(nr / 2) * wr * lspace + (nr - int(nr / 2) * 2)
+ * wr * ledgeeff pj=int(nr / 2) * lspace * 2 + (nr - int(nr / 2) * 2) * (2 * ledgeeff
+ + wr)
dsg ( si sb ) pdio_rf33_g area=1e-15 pj=wr * nr
ddg ( di db ) pdio_rf33_g area=1e-15 pj=wr * nr
//  ***************************************************************************
rb ( b bi ) resistor r=rb
cb ( b bi ) capacitor c=45.3f / rb
rdb ( db bi ) resistor r=rdb
cdb ( db bi ) capacitor c=45.3f / rdb
rsb ( sb bi ) resistor r=rdb
csb ( sb bi ) capacitor c=45.3f / rdb
m0 ( di gi si bi ) pch_rf33 l=lr w=wr m=nr ad=0 as=0 pd=0 ps=0

model pch_rf33 bsim3v3  {
 1: type=p
+ lmin=3.0e-007 lmax=5.001e-07 wmin=1.5000e-06
+ wmax=8.001e-06 tnom=25.0 version=3.24
+ tox=toxp_rf3 + toxmis toxm=6.77e-09 xj=1.7000001e-07
+ nch=4.9500000e17 lln=-1 lwn=1.0000000
+ wln=1.0000000 wwn=-1.0000000 lint=3.5000000e-08
+ ll=0.00 lw=0.00 lwl=0.00
+ wint=2.0000000e-08 wl=0.00 ww=0.00
+ wwl=0.00 mobmod=1 binunit=2
+ xl= - 0.02e-6 + dxlp_rf3 + dlmis xw=0.0 + dxwp_rf3 + dwmis
+ dwg=0.00 dwb=0.00
+ ldif=9.00e-08 hdif=hdifp_rf3 rsh=rshp_rf3
+ rd=0 rs=0
+ vth0= - 0.7727100 + dvthp_rf3 + vthmis
+ lvth0=2.6472314e-08 + dlvthp_rf3
+ wvth0=7.1924870e-08 + dwvthp_rf3
+ pvth0= - 2.1035541e-14 + dpvthp_rf3 k1=0.7699419
+ lk1=4.8013860e-08 wk1=-1.8243896e-09 pk1=-6.7361810e-15
+ k2=0.1315423 + dk2p_rf3 lk2= - 2.9673100e-08 + dlk2p_rf3
+ wk2=-2.7064845e-08 pk2=1.1859575e-14 k3=0.00
+ dvt0=0.00 dvt1=0.00 dvt2=0.00
+ dvt0w=0.00 dvt1w=0.00 dvt2w=0.00
+ nlx=0.00 w0=0.00 k3b=0.00
+ vsat=1.1960348e05 + dvsatp_rf3 lvsat=-3.9374090e-03
+ wvsat=8.9667880e-03 + dwvsatp_rf3 pvsat=-3.6763830e-09
+ ua=1.1489469e-09 lua=-1.5785002e-16 wua=7.2362290e-16
+ pua=-1.8122008e-22 ub=2.4514955e-19 lub=2.2735166e-25
+ wub=-1.3483237e-24 pub=3.1242082e-31 uc=-7.1838280e-11
+ luc=2.2854683e-17 wuc=-1.7606797e-16 puc=3.7125090e-23
+ rdsw=9.0000000e02 prwb=0.00 prwg=0.00
+ wr=1.0000000 u0=1.0090719e-02 + du0p_rf3
+ lu0= - 7.0264360e-11 + dlu0p_rf3
+ wu0= - 6.4404460e-10 + dwu0p_rf3
+ pu0=8.6706510e-17 + dpu0p_rf3 a0=1.1409379
+ la0=-8.2552040e-08 wa0=1.4760643e-07 pa0=-4.3866910e-14
+ keta=-1.1318877e-02 lketa=1.9036506e-09 wketa=1.4257295e-08
+ pketa=-7.1586210e-15 a1=0.00 a2=0.9900000
+ ags=2.0000000e-02 b0=0.00 b1=0.00
+ voff= - 0.1250223 + dvoffp_rf3
+ lvoff=8.9629090e-09 + dlvoffp_rf3
+ wvoff= - 9.4300550e-10 + dwvoffp_rf3
+ pvoff= - 2.9157947e-15 + dpvoffp_rf3
+ nfactor=1.0000000 + dnfactorp_rf3
+ pnfactor=0 + dpnfactorp_rf3
+ wnfactor=0 + dwnfactorp_rf3
+ lnfactor=0 + dlnfactorp_rf3 cit=5.6188450e-04
+ lcit=-2.1553027e-11 wcit=-1.5986783e-10 pcit=5.1946790e-17
+ cdsc=0.00 cdscb=0.00 cdscd=0.00
+ eta0= - 2.8413706e-04 + deta0p_rf3
+ leta0=1.5749620e-10 + dleta0p_rf3
+ weta0= - 3.5866790e-10 + dweta0p_rf3
+ peta0=1.4705383e-16 + dpeta0p_rf3 etab=8.7586620e-04
+ letab=-4.0010520e-10 wetab=-3.0878400e-10 petab=1.2660141e-16
+ dsub=0.00 pclm=0.6645077 lpclm=6.3411240e-09
+ wpclm=4.0103030e-08 ppclm=2.9485615e-15 pdiblc1=1.0000000e-06
+ pdiblc2=-3.7510620e-03 lpdiblc2=1.9479358e-09 wpdiblc2=5.5112340e-09
+ ppdiblc2=-2.2596061e-15 pdiblcb=1.0000000e-02 drout=0.00
+ pscbe1=3.3079310e08 lpscbe1=7.8748250 wpscbe1=-17.9333440
+ ppscbe1=7.3526710e-06 pscbe2=5.0000000e-07 pvag=0.00
+ delta=1.0000000e-02 alpha0=0.00 alpha1=0.143217238
+ beta0=16.10832 kt1=-0.3349694 lkt1=1.3342398e-08
+ wkt1=1.7269201e-09 pkt1=2.6498244e-15 kt2=-3.0737475e-02
+ lkt2=8.9807820e-10 wkt2=7.7649210e-10 pkt2=6.7802250e-17
+ at=-5.0000000e04 ute=-0.1318164 lute=-2.0271844e-07
+ wute=-3.7188310e-07 pute=2.1910628e-13 ua1=3.6255330e-09
+ lua1=-6.5375860e-16 wua1=-1.8496589e-15 pua1=7.5836000e-22
+ ub1=-2.5613780e-18 lub1=2.0065643e-25 wub1=6.1348050e-25
+ pub1=-2.3489589e-31 uc1=4.8751200e-11 luc1=-1.0675619e-17
+ wuc1=4.7864960e-17 puc1=-1.9370043e-25 kt1l=0.00
+ prt=0 cj=1.03531e-06 mj=0.3954951
+ pb=0.8049122 cjsw=2.23115e-13 mjsw=0.2573111
+ pbsw=0.8049122 cjswg=2.345762e-13 mjswg=0.2573111
+ pbswg=0.8049122 tpb=1.625007e-03 tpbsw=1.625007e-03
+ tcj=9.940197e-04 tcjsw=6.908749e-04 js=3.10e-06
+ jsw=2.80e-11 nj=1.0 xti=3.0
+ cgdo=1.218e-10 cgso=1.218e-10 cgbo=1.0e-13
+ capmod=3 nqsmod=0 elm=0
+ xpart=0 cf=0 tlev=1
+ tlevc=1 wwc=0.0342
+ dlc=4.847e-8 dwc=-2.064e-8 noff=1.847
+ lnoff=1.5e-7 acde=1.258 moin=10
+ voffcv=-0.045 cgsl=3.44e-10 cgdl=3.44e-10
+ wcf=4.066e-17 noimod=2 noia=2.0e+19
+ noib=8.0e+3 noic=5.4e-12 em=3.0e+07
+ ef=1.094
+ minr=1e-60 imax=0.01 imelt=0.01
//  )
     }
//  *************************************************************
//                       MODEL OF 3.3V P+/NW DIODE              *
//  *************************************************************
//  ** field edge diode  *******
model pdio_rf33_f diode level=1 tlevc=1 cj=cjp_rf3 mj=0.3954951 pb=0.8049122 cjsw=cjswp_rf3
+ mjsw=0.2573111 vjsw=0.8049122 cta=0.0009940197 ctp=0.0006908749 pta=0.001625007
+ ptp=0.001625007
//  **** gate edge diode *********
model pdio_rf33_g diode level=1 tlevc=1 cj=cjp_rf3 mj=0.3954951 pb=0.8049122 cjsw=cjswgp_rf3
+ mjsw=0.2573111 vjsw=0.8049122 cta=0.0009940197 ctp=0.0006908749 pta=0.001625007
+ ptp=0.001625007
//  ********************************
ends pmos_rf33_nw_mis

endsection rf_mos33

section rf_mim
//  ************************************************************************************************
//
//   MIM CAPACITOR MODEL :
//      HF model:
//         MiM_Cap w/i shield for 1PXM 4<=X<=6
//         MiM_Cap w/o shield for 1P6M
//
//      ## library files:
//
//      1. The MIM capacitors without Shield are modeled with sub-circuit 'mimcap_wos'
//
//
//       .subckt mimcap : Typical model
//
//      2. The MIM capacitors with Shield are modeled with sub-circuit 'mimcap_shield'
//
//
//       .subckt mimcap_shield : Typical model
//
//
//             Model name        lt              wt          unit
//                           low    high    low     high
//             ----------------------------------------------
//             mimcap         4      30      4       30       um
//             ----------------------------------------------
//             **lt: length dimension of top metal
//             **wt: width dimension of top metal
//             **lt >= wt
//  ************************************************************************************************
//
subckt mimcap_shield ( top bottom shield )
parameters lt=10u wt=10u
+ ltop_para=(wt * 0.11 * 1e6 - lt * 0.15 * 1e6 + 10.7) * 1e-12
+ lbot_para=(wt * 0.13 * 1e6 + lt * 0.43 * 1e6 + 10.7) * 1e-12
+ rtop_para=(8000 / (wt * lt * 1e12) + 150) * 1e-3
+ rbot_para=(3000 / (wt * lt * 1e12) + 268.7 + (lt / wt) * 28 + wt * 1e6 * 11.75) * 1e-3
+ cmim_para=((wt * lt * 1e12 * 1.025) + 2 * (wt + lt) * 1e6 * 0.2425) * 1e-15
+ cox_para=(((wt + 0.8e-6) * (lt + 0.8e-6) * 1e12 + ((wt + 3.4e-6) * 4.4e-6)
+ * 1e12) * 0.0396 + ((lt + 0.8e-6) * 0.01) * 1e6 + 1.0093) * 1e-15
//
model cmim_cap capacitor c=1.0f coeffs=[6.16e-5 -2.05e-5] tc1=-5.225e-5 tc2=1e-8 tnom=25
model rmim_res resistor tc1=5.16e-3 tc2=-1.34e-5 tnom=25
//
ltop ( top n1 ) inductor l=ltop_para * l_mimfac
rtop ( n1 n2 ) rmim_res r=rtop_para * rctm_mimfac
cmim ( n2 n3 ) cmim_cap c=cmim_para * cmim_mimfac
rbot ( n3 n4 ) rmim_res r=rbot_para * rctm_mimfac
lbot ( n4 bottom ) inductor l=lbot_para * l_mimfac
cox ( n3 shield ) capacitor c=cox_para * cm5_mimfac
//
//
ends mimcap_shield
//
//
subckt mimcap_wos ( top bottom gnode)
parameters lt=10u wt=10u
+ ltop_para=(wt * 0.11 * 1e6 - lt * 0.15 * 1e6 + 10.7) * 1e-12
+ lbot_para=(wt * 0.13 * 1e6 + lt * 0.43 * 1e6 + 10.7) * 1e-12
+ rtop_para=(8000 / (wt * lt * 1e12) + 150) * 1e-3
+ rbot_para=(3000 / (wt * lt * 1e12) + 268.7 + (lt / wt) * 28 + wt * 1e6 * 11.75) * 1e-3
+ cmim_para=((wt * lt * 1e12 * 1.025) + 2 * (wt + lt) * 1e6 * 0.2425) * 1e-15
+ cox_para=(((wt + 0.8e-6) * (lt + 0.8e-6) * 1e12 + ((wt + 3.4e-6) * 4.4e-6)
+ * 1e12 + ((lt + 0.8e-6 + 4.4e-6) * 1.5e-6) * 1e12) * 0.0056 + 0.2234) * 1e-15
+ csub_para=(((wt + (0.4e-6 + 7.1e-6) * 2) * (lt + (0.4e-6 + 2.2e-6 + 4e-6)
+ * 2)) * 1e12 * 0.0022) * 1e-15
+ rsub_para=29545 / (((wt + (0.4e-6 + 7.1e-6) * 2) * (lt + (0.4e-6 + 2.2e-6
+ + 4e-6) * 2)) * 1e12)
//
model cmim_cap capacitor c=1.0f coeffs=[6.16e-5 -2.05e-5] tc1=-5.225e-5 tc2=1e-8 tnom=25
model rmim_res resistor tc1=5.16e-3 tc2=-1.34e-5 tnom=25
//
ltop ( top n1 ) inductor l=ltop_para * l_mimfac
rtop ( n1 n2 ) rmim_res r=rtop_para * rctm_mimfac
cmim ( n2 n3 ) cmim_cap c=cmim_para * cmim_mimfac
rbot ( n3 n4 ) rmim_res r=rbot_para * rctm_mimfac
lbot ( n4 bottom ) inductor l=lbot_para * l_mimfac
cox ( n3 n5 ) capacitor c=cox_para * cm5_mimfac
csub ( n5 gnode ) capacitor c=csub_para * csub_mimfac
rsub ( n5 gnode ) resistor r=rsub_para * rsub_mimfac
//
ends mimcap_wos
//
//
endsection rf_mim

section rf_ind
//**************************************************************************************************
//  3) SPIRAL INDUCTOR MODEL :
//
//    HSPICE LEVEL 49:
//
//      ## library files:
//
//     The Inductors are modeled with sub-circuit 'spiral_s*_std', 'spiral_s*_sym', and 'spiral_s*_sym_ct'
//
//      .subckt spiral_s2_std  : Standard model with space=2um(fixed w=6um,9um,15um) for Inductance varies with turn(1/4turn increments) and radius
//      .subckt spiral_s3_std  : Standard model with space=3um(fixed w=30um) for Inductance varies with turn(1/4turn increments) and radius
//      .subckt spiral_s2_sym  : Symmetric model with space=2um(fixed w=9um,15um) for Inductance varies with turn(integral turn increments) and radius
//      .subckt spiral_s3_sym  : Symmetric model with space=3um(fixed w=30um) for Inductance varies with turn(integral turn increments) and radius
//      .subckt spiral_s2_sym_ct : Symmetric model(CT) with space=2um(fixed w=9um,15um) for Inductance varies with turn(odd turn increments) and radius
//      .subckt spiral_s3_sym_ct : Symmetric model(CT) with space=3um(fixed w=30um) for Inductance varies with turn(odd turn increments) and radius
//
//         Model name           turn          rad (um)
//                           low   high     low   high
//     ------------------------------------------------------
//     spiral_s2_std  W=6um  0.5   5.5      30     125
//                    W=9um  0.5   5.5      30     125
//                    W=15um 0.5   5.5      30     125
//     spiral_s3_std  W=30um 1.5   5.5      30     125
//     ------------------------------------------------------
//     spiral_s2_sym  W=9um    1     4      30     120
//                    W=15um   1     5      40     120
//     spiral_s3_sym  W=30um   1     5      65     150
//     ------------------------------------------------------
//     spiral_s2_sym_ct W=9um  1     3      30     120
//                      W=15um 1     5      40     120
//     spiral_s3_sym_ct W=30um 1     5      65     150
//      ------------------------------------------------------
//
//
//**************************************************************************************************

subckt spiral_s2_std ( top bottom gnode )
parameters nr=3 rad=60u w=15u lay=6
+di=2*rad*1e6
+do=2*(rad*1e6)+(int(nr+0.5)*(w*1e6+2)-2)+((int(nr)+1)*(w*1e6+2)-2)
+da=(di+do)/2
//
+c12_a=((w-9u)*(w-15u)/(6u-9u)/(6u-15u)*(7.446407929)+(w-6u)*(w-15u)/(9u-6u)/(9u-15u)*(7.921710563)+(w-6u)*(w-9u)/(15u-6u)/(15u-9u)*(14.87155616))
+c12_b=((w-9u)*(w-15u)/(6u-9u)/(6u-15u)*(0.020353705)+(w-6u)*(w-15u)/(9u-6u)/(9u-15u)*(0.021652878)+(w-6u)*(w-9u)/(15u-6u)/(15u-9u)*(-1.424902E-03))
+c12_c=((w-9u)*(w-15u)/(6u-9u)/(6u-15u)*(-0.9273399)+(w-6u)*(w-15u)/(9u-6u)/(9u-15u)*(-1.016531858)+(w-6u)*(w-9u)/(15u-6u)/(15u-9u)*(-1.239485341))
+c12_d=((w-9u)*(w-15u)/(6u-9u)/(6u-15u)*(0.000230493)+(w-6u)*(w-15u)/(9u-6u)/(9u-15u)*(0.000245206)+(w-6u)*(w-9u)/(15u-6u)/(15u-9u)*(3.621079E-04))
+c12_e=((w-9u)*(w-15u)/(6u-9u)/(6u-15u)*(-2.245782596)+(w-6u)*(w-15u)/(9u-6u)/(9u-15u)*(-2.389130422)+(w-6u)*(w-9u)/(15u-6u)/(15u-9u)*(-9.07586607))
//
+r1_a=((w-9u)*(w-15u)/(6u-9u)/(6u-15u)*(1.89298E-05)+(w-6u)*(w-15u)/(9u-6u)/(9u-15u)*(1.40221E-05)+(w-6u)*(w-9u)/(15u-6u)/(15u-9u)*(9.89795E-06))
+r1_b=((w-9u)*(w-15u)/(6u-9u)/(6u-15u)*(-0.237523798)+(w-6u)*(w-15u)/(9u-6u)/(9u-15u)*(-0.175943554)+(w-6u)*(w-9u)/(15u-6u)/(15u-9u)*(-0.124195 ))
+r1_c=((w-9u)*(w-15u)/(6u-9u)/(6u-15u)*(4.97757E-05)+(w-6u)*(w-15u)/(9u-6u)/(9u-15u)*(3.68709E-05)+(w-6u)*(w-9u)/(15u-6u)/(15u-9u)*(2.602649E-05))
+r1_d=((w-9u)*(w-15u)/(6u-9u)/(6u-15u)*(0.161252791)+(w-6u)*(w-15u)/(9u-6u)/(9u-15u)*(0.119446512)+(w-6u)*(w-9u)/(15u-6u)/(15u-9u)*(0.0843152 ))
+r1_e=((w-9u)*(w-15u)/(6u-9u)/(6u-15u)*(1.371319215)+(w-6u)*(w-15u)/(9u-6u)/(9u-15u)*(1.015792011)+(w-6u)*(w-9u)/(15u-6u)/(15u-9u)*(0.717029655))
//
+l1_a=((w-9u)*(w-15u)/(6u-9u)/(6u-15u)*(0.000615076)+(w-6u)*(w-15u)/(9u-6u)/(9u-15u)*(0.000575742)+(w-6u)*(w-9u)/(15u-6u)/(15u-9u)*(0.00043814 ))
+l1_b=((w-9u)*(w-15u)/(6u-9u)/(6u-15u)*(1.763177253)+(w-6u)*(w-15u)/(9u-6u)/(9u-15u)*(1.763177253)+(w-6u)*(w-9u)/(15u-6u)/(15u-9u)*(1.731275617))
+l1_c=((w-9u)*(w-15u)/(6u-9u)/(6u-15u)*(2.628046275)+(w-6u)*(w-15u)/(9u-6u)/(9u-15u)*(2.628046275)+(w-6u)*(w-9u)/(15u-6u)/(15u-9u)*(2.228105758))
+l1_d=((w-9u)*(w-15u)/(6u-9u)/(6u-15u)*(-1.4677342)+(w-6u)*(w-15u)/(9u-6u)/(9u-15u)*(-1.4677342)+(w-6u)*(w-9u)/(15u-6u)/(15u-9u)*(-1.034846428))
+l1_e=((w-9u)*(w-15u)/(6u-9u)/(6u-15u)*(0.000177222)+(w-6u)*(w-15u)/(9u-6u)/(9u-15u)*(0.000165888)+(w-6u)*(w-9u)/(15u-6u)/(15u-9u)*(-19.26896387))
+l1_f=((w-9u)*(w-15u)/(6u-9u)/(6u-15u)*(4.084061355)+(w-6u)*(w-15u)/(9u-6u)/(9u-15u)*(4.084061355)+(w-6u)*(w-9u)/(15u-6u)/(15u-9u)*(0.000996 ))
+l1_g=((w-9u)*(w-15u)/(6u-9u)/(6u-15u)*(0.083845656)+(w-6u)*(w-15u)/(9u-6u)/(9u-15u)*(0.078483653)+(w-6u)*(w-9u)/(15u-6u)/(15u-9u)*(19.3462888))
//
+rs_a=((w-9u)*(w-15u)/(6u-9u)/(6u-15u)*(7.80544E-06)+(w-6u)*(w-15u)/(9u-6u)/(9u-15u)*(5.20363E-06)+(w-6u)*(w-9u)/(15u-6u)/(15u-9u)*(3.46908E-06))
+rs_b=((w-9u)*(w-15u)/(6u-9u)/(6u-15u)*(1.957243755)+(w-6u)*(w-15u)/(9u-6u)/(9u-15u)*(1.30482917)+(w-6u)*(w-9u)/(15u-6u)/(15u-9u)*(0.869886114))
+rs_c=((w-9u)*(w-15u)/(6u-9u)/(6u-15u)*(0.008417873)+(w-6u)*(w-15u)/(9u-6u)/(9u-15u)*(0.005611916)+(w-6u)*(w-9u)/(15u-6u)/(15u-9u)*(0.003741277))
+rs_d=((w-9u)*(w-15u)/(6u-9u)/(6u-15u)*(-0.082355205)+(w-6u)*(w-15u)/(9u-6u)/(9u-15u)*(-0.05490347)+(w-6u)*(w-9u)/(15u-6u)/(15u-9u)*(-0.036602313))
+rs_e=((w-9u)*(w-15u)/(6u-9u)/(6u-15u)*(-1.072164624)+(w-6u)*(w-15u)/(9u-6u)/(9u-15u)*(-0.648109749)+(w-6u)*(w-9u)/(15u-6u)/(15u-9u)*(-0.3654065))
//
+ls_a=((w-9u)*(w-15u)/(6u-9u)/(6u-15u)*(0.833034575)+(w-6u)*(w-15u)/(9u-6u)/(9u-15u)*(0.779758365)+(w-6u)*(w-9u)/(15u-6u)/(15u-9u)*(0.717461208))
+ls_b=((w-9u)*(w-15u)/(6u-9u)/(6u-15u)*(1.063026324)+(w-6u)*(w-15u)/(9u-6u)/(9u-15u)*(1.063026324)+(w-6u)*(w-9u)/(15u-6u)/(15u-9u)*(1.063026324))
+ls_c=((w-9u)*(w-15u)/(6u-9u)/(6u-15u)*(-0.104300277)+(w-6u)*(w-15u)/(9u-6u)/(9u-15u)*(-0.104300277)+(w-6u)*(w-9u)/(15u-6u)/(15u-9u)*(-0.104300277))
+ls_d=((w-9u)*(w-15u)/(6u-9u)/(6u-15u)*(0.181461095)+(w-6u)*(w-15u)/(9u-6u)/(9u-15u)*(0.181461095)+(w-6u)*(w-9u)/(15u-6u)/(15u-9u)*(0.181461095))
+ls_e=((w-9u)*(w-15u)/(6u-9u)/(6u-15u)*(-1.094228077)+(w-6u)*(w-15u)/(9u-6u)/(9u-15u)*(-1.024247398)+(w-6u)*(w-9u)/(15u-6u)/(15u-9u)*(-0.942417 ))
+ls_f=((w-9u)*(w-15u)/(6u-9u)/(6u-15u)*(1.113650531)+(w-6u)*(w-15u)/(9u-6u)/(9u-15u)*(1.113650531)+(w-6u)*(w-9u)/(15u-6u)/(15u-9u)*(1.113650531))
+ls_g=((w-9u)*(w-15u)/(6u-9u)/(6u-15u)*(-0.041035841)+(w-6u)*(w-15u)/(9u-6u)/(9u-15u)*(-0.043048035)+(w-6u)*(w-9u)/(15u-6u)/(15u-9u)*(-0.049250624))
//
+cox1_a=((w-9u)*(w-15u)/(6u-9u)/(6u-15u)*(0.018858154)+(w-6u)*(w-15u)/(9u-6u)/(9u-15u)*(0.028287232)+(w-6u)*(w-9u)/(15u-6u)/(15u-9u)*(0.047145386))
+cox1_b=((w-9u)*(w-15u)/(6u-9u)/(6u-15u)*(5.709922019)+(w-6u)*(w-15u)/(9u-6u)/(9u-15u)*(8.564883029)+(w-6u)*(w-9u)/(15u-6u)/(15u-9u)*(14.27480505))
+cox2_a=((w-9u)*(w-15u)/(6u-9u)/(6u-15u)*(0.015978042)+(w-6u)*(w-15u)/(9u-6u)/(9u-15u)*(0.023967063)+(w-6u)*(w-9u)/(15u-6u)/(15u-9u)*(0.039945106))
+cox2_b=((w-9u)*(w-15u)/(6u-9u)/(6u-15u)*(6.086327293)+(w-6u)*(w-15u)/(9u-6u)/(9u-15u)*(9.129490939)+(w-6u)*(w-9u)/(15u-6u)/(15u-9u)*(15.21581823))
//
+rsub1_a=((w-9u)*(w-15u)/(6u-9u)/(6u-15u)*(156100)+(w-6u)*(w-15u)/(9u-6u)/(9u-15u)*(104066.6667)+(w-6u)*(w-9u)/(15u-6u)/(15u-9u)*(62440))
+rsub1_b=((w-9u)*(w-15u)/(6u-9u)/(6u-15u)*(113153.5)+(w-6u)*(w-15u)/(9u-6u)/(9u-15u)*(75435.66667)+(w-6u)*(w-9u)/(15u-6u)/(15u-9u)*(45261.4))
+rsub1_c=((w-9u)*(w-15u)/(6u-9u)/(6u-15u)*(3278.3)+(w-6u)*(w-15u)/(9u-6u)/(9u-15u)*(2185.533333)+(w-6u)*(w-9u)/(15u-6u)/(15u-9u)*(1311.32))
+rsub1_d=((w-9u)*(w-15u)/(6u-9u)/(6u-15u)*(-124.1475)+(w-6u)*(w-15u)/(9u-6u)/(9u-15u)*(-82.765)+(w-6u)*(w-9u)/(15u-6u)/(15u-9u)*(-49.659))
+rsub2_a=((w-9u)*(w-15u)/(6u-9u)/(6u-15u)*(-28542.61901)+(w-6u)*(w-15u)/(9u-6u)/(9u-15u)*(-19028.41267)+(w-6u)*(w-9u)/(15u-6u)/(15u-9u)*(-11417.0476))
+rsub2_b=((w-9u)*(w-15u)/(6u-9u)/(6u-15u)*(430505.2186)+(w-6u)*(w-15u)/(9u-6u)/(9u-15u)*(287003.4791)+(w-6u)*(w-9u)/(15u-6u)/(15u-9u)*(172202.0874))
+rsub2_c=((w-9u)*(w-15u)/(6u-9u)/(6u-15u)*(2165.73507)+(w-6u)*(w-15u)/(9u-6u)/(9u-15u)*(1443.82338)+(w-6u)*(w-9u)/(15u-6u)/(15u-9u)*(866.294028))
+rsub2_d=((w-9u)*(w-15u)/(6u-9u)/(6u-15u)*(325.3160133)+(w-6u)*(w-15u)/(9u-6u)/(9u-15u)*(216.8773422)+(w-6u)*(w-9u)/(15u-6u)/(15u-9u)*(130.1264053))
//
+cox_1=cox1_a*nr*da+cox1_b
+cox_2=cox2_a*nr*da+cox2_b
//
+rsub_1=(rsub1_a/(nr*da)+rsub1_b/da+rsub1_c/nr+rsub1_d)*(0.000027*(temp-25)*(temp-25)+0.00644586*(temp-25)+1)
+rsub_2=(rsub2_a/(nr*da)+rsub2_b/da+rsub2_c/nr+rsub2_d)*(0.000027*(temp-25)*(temp-25)+0.00644586*(temp-25)+1)
//
+csub_1=1.05315e-11/rsub_1
+csub_2=1.05315e-11/rsub_2
//
c12 ( top bottom ) capacitor c=(c12_a*nr+c12_b*nr*da+c12_c*nr*nr+c12_d*da*da+c12_e)*1e-15*c12_indfac

r1 ( top n1 ) resistor r=(r1_a*nr*da*da+r1_b*nr+r1_c*da+r1_d*nr*nr+r1_e)*(0.00328591*(temp-25)+1)*rm6_indfac
l1 ( n1 n3 ) inductor l=(l1_a*nr**(l1_b)*da**(l1_c)*do**(l1_d)+l1_e*nr**(l1_f)+l1_g)*1.0e-9 * l_indfac
l2 ( n3 n2 ) inductor l=(l1_a*nr**(l1_b)*da**(l1_c)*do**(l1_d)+l1_e*nr**(l1_f)+l1_g)*1.0e-9 * l_indfac
r2 ( n2 bottom) resistor r=(r1_a*nr*da*da+r1_b*nr+r1_c*da+r1_d*nr*nr+r1_e)*(0.00328591*(temp-25)+1)*rm6_indfac

rs1 ( top n11 ) resistor r=(rs_a*nr*da*da+rs_b*nr+rs_c*da+rs_d*nr*nr+rs_e)*(0.00328591*(temp-25)+1)*rsm6_indfac
ls1 ( n11 n1 ) inductor l= (ls_a*nr**(ls_b)*da**(ls_c)*do**(ls_d)+ls_e*nr**(ls_f)+ls_g)*1e-9 * lsm6_indfac
ls2 ( n22 n2 ) inductor l= (ls_a*nr**(ls_b)*da**(ls_c)*do**(ls_d)+ls_e*nr**(ls_f)+ls_g)*1e-9 * lsm6_indfac
rs2 ( n22 bottom ) resistor r=(rs_a*nr*da*da+rs_b*nr+rs_c*da+rs_d*nr*nr+rs_e)*(0.00328591*(temp-25)+1)*rsm6_indfac

cox1 ( top sub1 ) capacitor c=(cox_1)*((1/(7.67792+(4.14167)*(lay-2)))/(0.0412463))*1e-15 * cm6_indfac
cox2 ( bottom sub2 ) capacitor c=(cox_2)*((1/(7.67792+(4.14167)*(lay-2)))/(0.0412463))*1e-15 * cm6_indfac
cox3 ( n3 sub3 ) capacitor c=(cox_1+cox_2)*((1/(7.67792+(4.14167)*(lay-2)))/(0.0412463))*1e-15 * cm6_indfac

csub1 ( sub1 gnode ) capacitor c=(csub_1) * csub_indfac
csub2 ( sub2 gnode ) capacitor c=(csub_2) * csub_indfac
csub3 ( sub3 gnode ) capacitor c=(csub_1+csub_2) * csub_indfac
rsub1 ( sub1 gnode ) resistor r=(rsub_1)*rsub_indfac
rsub2 ( sub2 gnode ) resistor r=(rsub_2)*rsub_indfac
rsub3 ( sub3 gnode ) resistor r=(rsub_1*rsub_2/(rsub_1+rsub_2))*rsub_indfac

ends spiral_s2_std

subckt spiral_s3_std ( top bottom gnode )
parameters nr=3 rad=60u w=30u lay=6
+di=2*rad*1e6
+do=2*(rad*1e6)+(int(nr+0.5)*(w*1e6+3)-3)+((int(nr)+1)*(w*1e6+3)-3)
+da=(di+do)/2
//
+c12_a=((w-6u)*(w-9u)/(30u-6u)/(30u-9u)*(26.79131126))
+c12_b=((w-6u)*(w-9u)/(30u-6u)/(30u-9u)*(-0.037505172))
+c12_c=((w-6u)*(w-9u)/(30u-6u)/(30u-9u)*(-1.0407299))
+c12_d=((w-6u)*(w-9u)/(30u-6u)/(30u-9u)*(0.000527912))
+c12_e=((w-6u)*(w-9u)/(30u-6u)/(30u-9u)*(-23.22793157))
//
+r1_a=((w-6u)*(w-9u)/(30u-6u)/(30u-9u)*(1.72872E-06))
+r1_b=((w-6u)*(w-9u)/(30u-6u)/(30u-9u)*(0.113572489))
+r1_c=((w-6u)*(w-9u)/(30u-6u)/(30u-9u)*(0.000146495))
+r1_d=((w-6u)*(w-9u)/(30u-6u)/(30u-9u)*(0.056130932))
+r1_e=((w-6u)*(w-9u)/(30u-6u)/(30u-9u)*(0.313221103))
//
+l1_a=((w-6u)*(w-9u)/(30u-6u)/(30u-9u)*(0.000449115))
+l1_b=((w-6u)*(w-9u)/(30u-6u)/(30u-9u)*(1.725056335))
+l1_c=((w-6u)*(w-9u)/(30u-6u)/(30u-9u)*(2.290893594))
+l1_d=((w-6u)*(w-9u)/(30u-6u)/(30u-9u)*(-1.121284432))
+l1_e=((w-6u)*(w-9u)/(30u-6u)/(30u-9u)*(6.828092411))
+l1_f=((w-6u)*(w-9u)/(30u-6u)/(30u-9u)*(-13.56386811))
+l1_g=((w-6u)*(w-9u)/(30u-6u)/(30u-9u)*(0.044502767))
//
+rs_a=((w-6u)*(w-9u)/(30u-6u)/(30u-9u)*(1.73454E-06))
+rs_b=((w-6u)*(w-9u)/(30u-6u)/(30u-9u)*(0.434943057))
+rs_c=((w-6u)*(w-9u)/(30u-6u)/(30u-9u)*(0.001870639))
+rs_d=((w-6u)*(w-9u)/(30u-6u)/(30u-9u)*(-0.018301157))
+rs_e=((w-6u)*(w-9u)/(30u-6u)/(30u-9u)*(-0.28270325))
//
+ls_a=((w-6u)*(w-9u)/(30u-6u)/(30u-9u)*(5866693.815))
+ls_b=((w-6u)*(w-9u)/(30u-6u)/(30u-9u)*(4.496661508))
+ls_c=((w-6u)*(w-9u)/(30u-6u)/(30u-9u)*(14.58900228))
+ls_d=((w-6u)*(w-9u)/(30u-6u)/(30u-9u)*(-17.46893258))
+ls_e=((w-6u)*(w-9u)/(30u-6u)/(30u-9u)*(0.090628963))
+ls_f=((w-6u)*(w-9u)/(30u-6u)/(30u-9u)*(1.633495774))
+ls_g=((w-6u)*(w-9u)/(30u-6u)/(30u-9u)*(-0.134942332))
//
+cox1_a=((w-6u)*(w-9u)/(30u-6u)/(30u-9u)*(0.094290772))
+cox1_b=((w-6u)*(w-9u)/(30u-6u)/(30u-9u)*(28.5496101))
+cox2_a=((w-6u)*(w-9u)/(30u-6u)/(30u-9u)*(0.079890211))
+cox2_b=((w-6u)*(w-9u)/(30u-6u)/(30u-9u)*(30.43163646))
//
+rsub1_a=((w-6u)*(w-9u)/(30u-6u)/(30u-9u)*(31220))
+rsub1_b=((w-6u)*(w-9u)/(30u-6u)/(30u-9u)*(22630.7))
+rsub1_c=((w-6u)*(w-9u)/(30u-6u)/(30u-9u)*(655.66))
+rsub1_d=((w-6u)*(w-9u)/(30u-6u)/(30u-9u)*(-24.8295))
+rsub2_a=((w-6u)*(w-9u)/(30u-6u)/(30u-9u)*(-5708.523802))
+rsub2_b=((w-6u)*(w-9u)/(30u-6u)/(30u-9u)*(86101.04372))
+rsub2_c=((w-6u)*(w-9u)/(30u-6u)/(30u-9u)*(433.147014))
+rsub2_d=((w-6u)*(w-9u)/(30u-6u)/(30u-9u)*(65.06320265))
//
+cox_1=cox1_a*nr*da+cox1_b
+cox_2=cox2_a*nr*da+cox2_b
//
+rsub_1=(rsub1_a/(nr*da)+rsub1_b/da+rsub1_c/nr+rsub1_d)*(0.000027*(temp-25)*(temp-25)+0.00644586*(temp-25)+1)
+rsub_2=(rsub2_a/(nr*da)+rsub2_b/da+rsub2_c/nr+rsub2_d)*(0.000027*(temp-25)*(temp-25)+0.00644586*(temp-25)+1)
//
+csub_1=1.05315e-11/rsub_1
+csub_2=1.05315e-11/rsub_2
//
c12 ( top bottom ) capacitor c=(c12_a*nr+c12_b*nr*da+c12_c*nr*nr+c12_d*da*da+c12_e)*1e-15*c12_indfac

r1 ( top n1 ) resistor r=(r1_a*nr*da*da+r1_b*nr+r1_c*da+r1_d*nr*nr+r1_e)*(0.00328591*(temp-25)+1)*rm6_indfac
l1 ( n1 n3 ) inductor l=(l1_a*nr**(l1_b)*da**(l1_c)*do**(l1_d)+l1_e*nr**(l1_f)+l1_g)*1.0e-9 * l_indfac
l2 ( n3 n2 ) inductor l=(l1_a*nr**(l1_b)*da**(l1_c)*do**(l1_d)+l1_e*nr**(l1_f)+l1_g)*1.0e-9 * l_indfac
r2 ( n2 bottom) resistor r=(r1_a*nr*da*da+r1_b*nr+r1_c*da+r1_d*nr*nr+r1_e)*(0.00328591*(temp-25)+1)*rm6_indfac

rs1 ( top n11 ) resistor r=(rs_a*nr*da*da+rs_b*nr+rs_c*da+rs_d*nr*nr+rs_e)*(0.00328591*(temp-25)+1)*rsm6_indfac
ls1 ( n11 n1 ) inductor l= (ls_a*nr**(ls_b)*da**(ls_c)*do**(ls_d)+ls_e*nr**(ls_f)+ls_g)*1e-9 * lsm6_indfac
ls2 ( n22 n2 ) inductor l= (ls_a*nr**(ls_b)*da**(ls_c)*do**(ls_d)+ls_e*nr**(ls_f)+ls_g)*1e-9 * lsm6_indfac
rs2 ( n22 bottom ) resistor r=(rs_a*nr*da*da+rs_b*nr+rs_c*da+rs_d*nr*nr+rs_e)*(0.00328591*(temp-25)+1)*rsm6_indfac

cox1 ( top sub1 ) capacitor c=(cox_1)*((1/(7.67792+(4.14167)*(lay-2)))/(0.0412463))*1e-15 * cm6_indfac
cox2 ( bottom sub2 ) capacitor c=(cox_2)*((1/(7.67792+(4.14167)*(lay-2)))/(0.0412463))*1e-15 * cm6_indfac
cox3 ( n3 sub3 ) capacitor c=(cox_1+cox_2)*((1/(7.67792+(4.14167)*(lay-2)))/(0.0412463))*1e-15 * cm6_indfac

csub1 ( sub1 gnode ) capacitor c=(csub_1) * csub_indfac
csub2 ( sub2 gnode ) capacitor c=(csub_2) * csub_indfac
csub3 ( sub3 gnode ) capacitor c=(csub_1+csub_2) * csub_indfac
rsub1 ( sub1 gnode ) resistor r=(rsub_1)*rsub_indfac
rsub2 ( sub2 gnode ) resistor r=(rsub_2)*rsub_indfac
rsub3 ( sub3 gnode ) resistor r=(rsub_1*rsub_2/(rsub_1+rsub_2))*rsub_indfac

ends spiral_s3_std

subckt spiral_s2_sym ( top bottom gnode )
parameters nr=3 rad=60u w=15u lay=6
+di=2*rad*1e6
+do=2*rad*1e6+2*(nr*(w*1e6+2)-2)
+da=(di+do)/2
//
+c12_a=((w-6u)*(w-15u)/(9u-6u)/(9u-15u)*(3.208353228)+(w-6u)*(w-9u)/(15u-6u)/(15u-9u)*(3.208353228))
+c12_b=((w-6u)*(w-15u)/(9u-6u)/(9u-15u)*(0.083306298)+(w-6u)*(w-9u)/(15u-6u)/(15u-9u)*(0.083306298))
+c12_c=((w-6u)*(w-15u)/(9u-6u)/(9u-15u)*(0.434821499)+(w-6u)*(w-9u)/(15u-6u)/(15u-9u)*(0.434821499))
+c12_d=((w-6u)*(w-15u)/(9u-6u)/(9u-15u)*(-5.02673E-05)+(w-6u)*(w-9u)/(15u-6u)/(15u-9u)*(-5.02673E-05))
+c12_e=((w-6u)*(w-15u)/(9u-6u)/(9u-15u)*(-9.004140494)+(w-6u)*(w-9u)/(15u-6u)/(15u-9u)*(-11.00414049))
//
+r1_a=((w-6u)*(w-15u)/(9u-6u)/(9u-15u)*(1.04692E-05)+(w-6u)*(w-9u)/(15u-6u)/(15u-9u)*(7.64142E-06))
+r1_b=((w-6u)*(w-15u)/(9u-6u)/(9u-15u)*(-0.086011588)+(w-6u)*(w-9u)/(15u-6u)/(15u-9u)*(-0.394782))
+r1_c=((w-6u)*(w-15u)/(9u-6u)/(9u-15u)*(-0.001447463)+(w-6u)*(w-9u)/(15u-6u)/(15u-9u)*(-0.00145037))
+r1_d=((w-6u)*(w-15u)/(9u-6u)/(9u-15u)*(0.117997937)+(w-6u)*(w-9u)/(15u-6u)/(15u-9u)*(0.155148182))
+r1_e=((w-6u)*(w-15u)/(9u-6u)/(9u-15u)*(0.915656873)+(w-6u)*(w-9u)/(15u-6u)/(15u-9u)*(1.067333992))
//
+l1_a=((w-6u)*(w-15u)/(9u-6u)/(9u-15u)*(0.000493985)+(w-6u)*(w-9u)/(15u-6u)/(15u-9u)*(0.000454519))
+l1_b=((w-6u)*(w-15u)/(9u-6u)/(9u-15u)*(1.492874307)+(w-6u)*(w-9u)/(15u-6u)/(15u-9u)*(1.492874307))
+l1_c=((w-6u)*(w-15u)/(9u-6u)/(9u-15u)*(1.866776963)+(w-6u)*(w-9u)/(15u-6u)/(15u-9u)*(1.866776963))
+l1_d=((w-6u)*(w-15u)/(9u-6u)/(9u-15u)*(-0.720186949)+(w-6u)*(w-9u)/(15u-6u)/(15u-9u)*(-0.720186949))
+l1_e=((w-6u)*(w-15u)/(9u-6u)/(9u-15u)*(6.185873613)+(w-6u)*(w-9u)/(15u-6u)/(15u-9u)*(5.691666234))
+l1_f=((w-6u)*(w-15u)/(9u-6u)/(9u-15u)*(-0.009655841)+(w-6u)*(w-9u)/(15u-6u)/(15u-9u)*(-0.009655841))
+l1_g=((w-6u)*(w-15u)/(9u-6u)/(9u-15u)*(-6.153823487)+(w-6u)*(w-9u)/(15u-6u)/(15u-9u)*(-5.656656043))
//
+m_a=((w-6u)*(w-15u)/(9u-6u)/(9u-15u)*(7.536628471)+(w-6u)*(w-9u)/(15u-6u)/(15u-9u)*(0.928263647))
+m_b=((w-6u)*(w-15u)/(9u-6u)/(9u-15u)*(0.027843479)+(w-6u)*(w-9u)/(15u-6u)/(15u-9u)*(0.3660))
+m_c=((w-6u)*(w-15u)/(9u-6u)/(9u-15u)*(0.111597388)+(w-6u)*(w-9u)/(15u-6u)/(15u-9u)*(2.44086458))
+m_d=((w-6u)*(w-15u)/(9u-6u)/(9u-15u)*(-0.115535359)+(w-6u)*(w-9u)/(15u-6u)/(15u-9u)*(-2.574605098))
+m_e=((w-6u)*(w-15u)/(9u-6u)/(9u-15u)*(49.56343638)+(w-6u)*(w-9u)/(15u-6u)/(15u-9u)*(0.901142915))
+m_f=((w-6u)*(w-15u)/(9u-6u)/(9u-15u)*(0.005308)+(w-6u)*(w-9u)/(15u-6u)/(15u-9u)*(0.300190549))
+m_g=((w-6u)*(w-15u)/(9u-6u)/(9u-15u)*(-56.87037564)+(w-6u)*(w-9u)/(15u-6u)/(15u-9u)*(-1.2304))
//
+rs_a=((w-6u)*(w-15u)/(9u-6u)/(9u-15u)*(7.75609E-06)+(w-6u)*(w-9u)/(15u-6u)/(15u-9u)*(4.65365E-06))
+rs_b=((w-6u)*(w-15u)/(9u-6u)/(9u-15u)*(0.22777492)+(w-6u)*(w-9u)/(15u-6u)/(15u-9u)*(0.136664952))
+rs_c=((w-6u)*(w-15u)/(9u-6u)/(9u-15u)*(0.004655002)+(w-6u)*(w-9u)/(15u-6u)/(15u-9u)*(0.002793001))
+rs_d=((w-6u)*(w-15u)/(9u-6u)/(9u-15u)*(0.141680458)+(w-6u)*(w-9u)/(15u-6u)/(15u-9u)*(0.085008275))
+rs_e=((w-6u)*(w-15u)/(9u-6u)/(9u-15u)*(-0.345424039)+(w-6u)*(w-9u)/(15u-6u)/(15u-9u)*(-0.303254423))
//
+ls_a=((w-6u)*(w-15u)/(9u-6u)/(9u-15u)*(10.73727659)+(w-6u)*(w-9u)/(15u-6u)/(15u-9u)*(16.77187369))
+ls_b=((w-6u)*(w-15u)/(9u-6u)/(9u-15u)*(0.267266877)+(w-6u)*(w-9u)/(15u-6u)/(15u-9u)*(0.205407639))
+ls_c=((w-6u)*(w-15u)/(9u-6u)/(9u-15u)*(0.104275199)+(w-6u)*(w-9u)/(15u-6u)/(15u-9u)*(0.068539016))
+ls_d=((w-6u)*(w-15u)/(9u-6u)/(9u-15u)*(-0.107910008)+(w-6u)*(w-9u)/(15u-6u)/(15u-9u)*(-0.071972792))
+ls_e=((w-6u)*(w-15u)/(9u-6u)/(9u-15u)*(-194.3280388)+(w-6u)*(w-9u)/(15u-6u)/(15u-9u)*(-655.2555978))
+ls_f=((w-6u)*(w-15u)/(9u-6u)/(9u-15u)*(0.013998487)+(w-6u)*(w-9u)/(15u-6u)/(15u-9u)*(0.005029712))
+ls_g=((w-6u)*(w-15u)/(9u-6u)/(9u-15u)*(183.9159828)+(w-6u)*(w-9u)/(15u-6u)/(15u-9u)*(638.929009))
//
+cox_a=((w-6u)*(w-15u)/(9u-6u)/(9u-15u)*(0.023460082)+(w-6u)*(w-9u)/(15u-6u)/(15u-9u)*(0.039100136))
+cox_b=((w-6u)*(w-15u)/(9u-6u)/(9u-15u)*(6.271136653)+(w-6u)*(w-9u)/(15u-6u)/(15u-9u)*(10.45189442))
//
+rsub_a=((w-6u)*(w-15u)/(9u-6u)/(9u-15u)*(88352.98446)+(w-6u)*(w-9u)/(15u-6u)/(15u-9u)*(53011.79068))
+rsub_b=((w-6u)*(w-15u)/(9u-6u)/(9u-15u)*(75193.48724)+(w-6u)*(w-9u)/(15u-6u)/(15u-9u)*(45116.09234))
+rsub_c=((w-6u)*(w-15u)/(9u-6u)/(9u-15u)*(2778.049752)+(w-6u)*(w-9u)/(15u-6u)/(15u-9u)*(1666.829851))
+rsub_d=((w-6u)*(w-15u)/(9u-6u)/(9u-15u)*(-658.4666447)+(w-6u)*(w-9u)/(15u-6u)/(15u-9u)*(-395.0799868))
//
+cox_1=cox_a*nr*da+cox_b
+cox_2=cox_a*nr*da+cox_b
//
+rsub_1=(rsub_a/(nr*da)+rsub_b/da+rsub_c/nr+rsub_d)*(0.000027*(temp-25)*(temp-25)+0.00644586*(temp-25)+1)
+rsub_2=(rsub_a/(nr*da)+rsub_b/da+rsub_c/nr+rsub_d)*(0.000027*(temp-25)*(temp-25)+0.00644586*(temp-25)+1)
//
+csub_1=1.05315e-11/rsub_1
+csub_2=1.05315e-11/rsub_2
//
c12 ( top bottom ) capacitor c=(c12_a*nr+c12_b*nr*da+c12_c*nr*nr+c12_d*da*da+c12_e)*1e-15*c12_indfac

r1 ( top n1 ) resistor r=(r1_a*nr*da*da+r1_b*nr+r1_c*da+r1_d*nr*nr+r1_e)*(0.00328591*(temp-25)+1)*rm6_indfac
l1 ( n1 n3 ) inductor l=(l1_a*nr**(l1_b)*da**(l1_c)*do**(l1_d)+l1_e*nr**(l1_f)+l1_g)*1.0e-9 * l_indfac
l2 ( n3 n2 ) inductor l=(l1_a*nr**(l1_b)*da**(l1_c)*do**(l1_d)+l1_e*nr**(l1_f)+l1_g)*1.0e-9 * l_indfac
r2 ( n2 bottom) resistor r=(r1_a*nr*da*da+r1_b*nr+r1_c*da+r1_d*nr*nr+r1_e)*(0.00328591*(temp-25)+1)*rm6_indfac

ml1 mutual_inductor coupling=(m_a*nr**(m_b)*da**(m_c)*do**(m_d)+m_e*nr**(m_f)+m_g) * k_indfac ind1=l1 ind2=l2

rs1 ( top n11 ) resistor r=(rs_a*nr*da*da+rs_b*nr+rs_c*da+rs_d*nr*nr+rs_e)*(0.00328591*(temp-25)+1)*rsm6_indfac
ls1 ( n11 n1 ) inductor l= (ls_a*nr**(ls_b)*da**(ls_c)*do**(ls_d)+ls_e*nr**(ls_f)+ls_g)*1e-9 * lsm6_indfac
ls2 ( n22 n2 ) inductor l= (ls_a*nr**(ls_b)*da**(ls_c)*do**(ls_d)+ls_e*nr**(ls_f)+ls_g)*1e-9 * lsm6_indfac
rs2 ( n22 bottom ) resistor r=(rs_a*nr*da*da+rs_b*nr+rs_c*da+rs_d*nr*nr+rs_e)*(0.00328591*(temp-25)+1)*rsm6_indfac

cox1 ( top sub1 ) capacitor c=(cox_1)*((1/(7.67792+(4.14167)*(lay-2)))/(0.0412463))*1e-15 * cm6_indfac
cox2 ( bottom sub2 ) capacitor c=(cox_2)*((1/(7.67792+(4.14167)*(lay-2)))/(0.0412463))*1e-15 * cm6_indfac
cox3 ( n3 sub3 ) capacitor c=(cox_1+cox_2)*((1/(7.67792+(4.14167)*(lay-2)))/(0.0412463))*1e-15 * cm6_indfac

csub1 ( sub1 gnode ) capacitor c=(csub_1) * csub_indfac
csub2 ( sub2 gnode ) capacitor c=(csub_2) * csub_indfac
csub3 ( sub3 gnode ) capacitor c=(csub_1+csub_2) * csub_indfac
rsub1 ( sub1 gnode ) resistor r=(rsub_1)*rsub_indfac
rsub2 ( sub2 gnode ) resistor r=(rsub_2)*rsub_indfac
rsub3 ( sub3 gnode ) resistor r=(rsub_1*rsub_2/(rsub_1+rsub_2))*rsub_indfac

ends spiral_s2_sym

subckt spiral_s3_sym ( top bottom gnode )
parameters nr=3 rad=60u w=30u lay=6
+di=2*rad*1e6
+do=2*rad*1e6+2*(nr*(w*1e6+3)-3)
+da=(di+do)/2
//
+c12_a=((w-6u)*(w-9u)/(30u-6u)/(30u-9u)*(10.00435358))
+c12_b=((w-6u)*(w-9u)/(30u-6u)/(30u-9u)*(0.111537616))
+c12_c=((w-6u)*(w-9u)/(30u-6u)/(30u-9u)*(-1.369840122))
+c12_d=((w-6u)*(w-9u)/(30u-6u)/(30u-9u)*(-0.000139208))
+c12_e=((w-6u)*(w-9u)/(30u-6u)/(30u-9u)*(-22.49856825))
//
+r1_a=((w-6u)*(w-9u)/(30u-6u)/(30u-9u)*(1.0841E-06))
+r1_b=((w-6u)*(w-9u)/(30u-6u)/(30u-9u)*(-0.048048881))
+r1_c=((w-6u)*(w-9u)/(30u-6u)/(30u-9u)*(6.83388E-05))
+r1_d=((w-6u)*(w-9u)/(30u-6u)/(30u-9u)*(0.101386734))
+r1_e=((w-6u)*(w-9u)/(30u-6u)/(30u-9u)*(0.451179252))
//
+l1_a=((w-6u)*(w-9u)/(30u-6u)/(30u-9u)*(0.000405963))
+l1_b=((w-6u)*(w-9u)/(30u-6u)/(30u-9u)*(1.492874307))
+l1_c=((w-6u)*(w-9u)/(30u-6u)/(30u-9u)*(1.866776963))
+l1_d=((w-6u)*(w-9u)/(30u-6u)/(30u-9u)*(-0.720186949))
+l1_e=((w-6u)*(w-9u)/(30u-6u)/(30u-9u)*(5.08362553))
+l1_f=((w-6u)*(w-9u)/(30u-6u)/(30u-9u)*(-0.009655841))
+l1_g=((w-6u)*(w-9u)/(30u-6u)/(30u-9u)*(-5.062355478))
//
+m_a=((w-6u)*(w-9u)/(30u-6u)/(30u-9u)*(0.905447014))
+m_b=((w-6u)*(w-9u)/(30u-6u)/(30u-9u)*(1.261301827))
+m_c=((w-6u)*(w-9u)/(30u-6u)/(30u-9u)*(4.20674721))
+m_d=((w-6u)*(w-9u)/(30u-6u)/(30u-9u)*(-4.477699893))
+m_e=((w-6u)*(w-9u)/(30u-6u)/(30u-9u)*(0.136190791))
+m_f=((w-6u)*(w-9u)/(30u-6u)/(30u-9u)*(0.76704561))
+m_g=((w-6u)*(w-9u)/(30u-6u)/(30u-9u)*(-0.240172913))
//
+rs_a=((w-6u)*(w-9u)/(30u-6u)/(30u-9u)*(2.32683E-06))
+rs_b=((w-6u)*(w-9u)/(30u-6u)/(30u-9u)*(0.068332476))
+rs_c=((w-6u)*(w-9u)/(30u-6u)/(30u-9u)*(0.001396501))
+rs_d=((w-6u)*(w-9u)/(30u-6u)/(30u-9u)*(0.042504137))
+rs_e=((w-6u)*(w-9u)/(30u-6u)/(30u-9u)*(-0.151627212))
//
+ls_a=((w-6u)*(w-9u)/(30u-6u)/(30u-9u)*(-2.991172483))
+ls_b=((w-6u)*(w-9u)/(30u-6u)/(30u-9u)*(2.742014108))
+ls_c=((w-6u)*(w-9u)/(30u-6u)/(30u-9u)*(0.545707143))
+ls_d=((w-6u)*(w-9u)/(30u-6u)/(30u-9u)*(-0.852820095))
+ls_e=((w-6u)*(w-9u)/(30u-6u)/(30u-9u)*(0.650076602))
+ls_f=((w-6u)*(w-9u)/(30u-6u)/(30u-9u)*(2.399142092))
+ls_g=((w-6u)*(w-9u)/(30u-6u)/(30u-9u)*(-0.087336698))
//
+cox_a=((w-6u)*(w-9u)/(30u-6u)/(30u-9u)*(0.062560218))
+cox_b=((w-6u)*(w-9u)/(30u-6u)/(30u-9u)*(16.72303108))
//
+rsub_a=((w-6u)*(w-9u)/(30u-6u)/(30u-9u)*(26505.89534))
+rsub_b=((w-6u)*(w-9u)/(30u-6u)/(30u-9u)*(22558.04617))
+rsub_c=((w-6u)*(w-9u)/(30u-6u)/(30u-9u)*(833.4149256))
+rsub_d=((w-6u)*(w-9u)/(30u-6u)/(30u-9u)*(-97.53999341))
//
+cox_1=cox_a*nr*da+cox_b
+cox_2=cox_a*nr*da+cox_b
//
+rsub_1=(rsub_a/(nr*da)+rsub_b/da+rsub_c/nr+rsub_d)*(0.000027*(temp-25)*(temp-25)+0.00644586*(temp-25)+1)
+rsub_2=(rsub_a/(nr*da)+rsub_b/da+rsub_c/nr+rsub_d)*(0.000027*(temp-25)*(temp-25)+0.00644586*(temp-25)+1)
//
+csub_1=1.05315e-11/rsub_1
+csub_2=1.05315e-11/rsub_2
//
c12 ( top bottom ) capacitor c=(c12_a*nr+c12_b*nr*da+c12_c*nr*nr+c12_d*da*da+c12_e)*1e-15*c12_indfac

r1 ( top n1 ) resistor r=(r1_a*nr*da*da+r1_b*nr+r1_c*da+r1_d*nr*nr+r1_e)*(0.00328591*(temp-25)+1)*rm6_indfac
l1 ( n1 n3 ) inductor l=(l1_a*nr**(l1_b)*da**(l1_c)*do**(l1_d)+l1_e*nr**(l1_f)+l1_g)*1.0e-9 * l_indfac
l2 ( n3 n2 ) inductor l=(l1_a*nr**(l1_b)*da**(l1_c)*do**(l1_d)+l1_e*nr**(l1_f)+l1_g)*1.0e-9 * l_indfac
r2 ( n2 bottom) resistor r=(r1_a*nr*da*da+r1_b*nr+r1_c*da+r1_d*nr*nr+r1_e)*(0.00328591*(temp-25)+1)*rm6_indfac

ml1 mutual_inductor coupling=(m_a*nr**(m_b)*da**(m_c)*do**(m_d)+m_e*nr**(m_f)+m_g) * k_indfac ind1=l1 ind2=l2

rs1 ( top n11 ) resistor r=(rs_a*nr*da*da+rs_b*nr+rs_c*da+rs_d*nr*nr+rs_e)*(0.00328591*(temp-25)+1)*rsm6_indfac
ls1 ( n11 n1 ) inductor l= (ls_a*nr**(ls_b)*da**(ls_c)*do**(ls_d)+ls_e*nr**(ls_f)+ls_g)*1e-9 * lsm6_indfac
ls2 ( n22 n2 ) inductor l= (ls_a*nr**(ls_b)*da**(ls_c)*do**(ls_d)+ls_e*nr**(ls_f)+ls_g)*1e-9 * lsm6_indfac
rs2 ( n22 bottom ) resistor r=(rs_a*nr*da*da+rs_b*nr+rs_c*da+rs_d*nr*nr+rs_e)*(0.00328591*(temp-25)+1)*rsm6_indfac

cox1 ( top sub1 ) capacitor c=(cox_1)*((1/(7.67792+(4.14167)*(lay-2)))/(0.0412463))*1e-15 * cm6_indfac
cox2 ( bottom sub2 ) capacitor c=(cox_2)*((1/(7.67792+(4.14167)*(lay-2)))/(0.0412463))*1e-15 * cm6_indfac
cox3 ( n3 sub3 ) capacitor c=(cox_1+cox_2)*((1/(7.67792+(4.14167)*(lay-2)))/(0.0412463))*1e-15 * cm6_indfac

csub1 ( sub1 gnode ) capacitor c=(csub_1) * csub_indfac
csub2 ( sub2 gnode ) capacitor c=(csub_2) * csub_indfac
csub3 ( sub3 gnode ) capacitor c=(csub_1+csub_2) * csub_indfac
rsub1 ( sub1 gnode ) resistor r=(rsub_1)*rsub_indfac
rsub2 ( sub2 gnode ) resistor r=(rsub_2)*rsub_indfac
rsub3 ( sub3 gnode ) resistor r=(rsub_1*rsub_2/(rsub_1+rsub_2))*rsub_indfac

ends spiral_s3_sym

subckt spiral_s2_sym_ct ( top bottom gnode tap )
parameters nr=3 rad=60u w=15u lay=6
+di=2*rad*1e6
+do=2*rad*1e6+2*(nr*(w*1e6+2)-2)
+da=(di+do)/2
//
+c12_a=((w-6u)*(w-15u)/(9u-6u)/(9u-15u)*(3.208353228)+(w-6u)*(w-9u)/(15u-6u)/(15u-9u)*(3.208353228))
+c12_b=((w-6u)*(w-15u)/(9u-6u)/(9u-15u)*(0.083306298)+(w-6u)*(w-9u)/(15u-6u)/(15u-9u)*(0.083306298))
+c12_c=((w-6u)*(w-15u)/(9u-6u)/(9u-15u)*(0.434821499)+(w-6u)*(w-9u)/(15u-6u)/(15u-9u)*(0.434821499))
+c12_d=((w-6u)*(w-15u)/(9u-6u)/(9u-15u)*(-5.02673E-05)+(w-6u)*(w-9u)/(15u-6u)/(15u-9u)*(-5.02673E-05))
+c12_e=((w-6u)*(w-15u)/(9u-6u)/(9u-15u)*(-9.004140494)+(w-6u)*(w-9u)/(15u-6u)/(15u-9u)*(-11.00414049))
//
+r1_a=((w-6u)*(w-15u)/(9u-6u)/(9u-15u)*(1.04692E-05)+(w-6u)*(w-9u)/(15u-6u)/(15u-9u)*(7.64142E-06))
+r1_b=((w-6u)*(w-15u)/(9u-6u)/(9u-15u)*(-0.086011588)+(w-6u)*(w-9u)/(15u-6u)/(15u-9u)*(-0.394782))
+r1_c=((w-6u)*(w-15u)/(9u-6u)/(9u-15u)*(-0.001447463)+(w-6u)*(w-9u)/(15u-6u)/(15u-9u)*(-0.00145037))
+r1_d=((w-6u)*(w-15u)/(9u-6u)/(9u-15u)*(0.117997937)+(w-6u)*(w-9u)/(15u-6u)/(15u-9u)*(0.155148182))
+r1_e=((w-6u)*(w-15u)/(9u-6u)/(9u-15u)*(0.915656873)+(w-6u)*(w-9u)/(15u-6u)/(15u-9u)*(1.067333992))
//
+l1_a=((w-6u)*(w-15u)/(9u-6u)/(9u-15u)*(0.000493985)+(w-6u)*(w-9u)/(15u-6u)/(15u-9u)*(0.000454519))
+l1_b=((w-6u)*(w-15u)/(9u-6u)/(9u-15u)*(1.492874307)+(w-6u)*(w-9u)/(15u-6u)/(15u-9u)*(1.492874307))
+l1_c=((w-6u)*(w-15u)/(9u-6u)/(9u-15u)*(1.866776963)+(w-6u)*(w-9u)/(15u-6u)/(15u-9u)*(1.866776963))
+l1_d=((w-6u)*(w-15u)/(9u-6u)/(9u-15u)*(-0.720186949)+(w-6u)*(w-9u)/(15u-6u)/(15u-9u)*(-0.720186949))
+l1_e=((w-6u)*(w-15u)/(9u-6u)/(9u-15u)*(6.185873613)+(w-6u)*(w-9u)/(15u-6u)/(15u-9u)*(5.691666234))
+l1_f=((w-6u)*(w-15u)/(9u-6u)/(9u-15u)*(-0.009655841)+(w-6u)*(w-9u)/(15u-6u)/(15u-9u)*(-0.009655841))
+l1_g=((w-6u)*(w-15u)/(9u-6u)/(9u-15u)*(-6.153823487)+(w-6u)*(w-9u)/(15u-6u)/(15u-9u)*(-5.656656043))
//
+m_a=((w-6u)*(w-15u)/(9u-6u)/(9u-15u)*(7.536628471)+(w-6u)*(w-9u)/(15u-6u)/(15u-9u)*(0.928263647))
+m_b=((w-6u)*(w-15u)/(9u-6u)/(9u-15u)*(0.027843479)+(w-6u)*(w-9u)/(15u-6u)/(15u-9u)*(0.3660))
+m_c=((w-6u)*(w-15u)/(9u-6u)/(9u-15u)*(0.111597388)+(w-6u)*(w-9u)/(15u-6u)/(15u-9u)*(2.44086458))
+m_d=((w-6u)*(w-15u)/(9u-6u)/(9u-15u)*(-0.115535359)+(w-6u)*(w-9u)/(15u-6u)/(15u-9u)*(-2.574605098))
+m_e=((w-6u)*(w-15u)/(9u-6u)/(9u-15u)*(49.56343638)+(w-6u)*(w-9u)/(15u-6u)/(15u-9u)*(0.901142915))
+m_f=((w-6u)*(w-15u)/(9u-6u)/(9u-15u)*(0.005308)+(w-6u)*(w-9u)/(15u-6u)/(15u-9u)*(0.300190549))
+m_g=((w-6u)*(w-15u)/(9u-6u)/(9u-15u)*(-56.87037564)+(w-6u)*(w-9u)/(15u-6u)/(15u-9u)*(-1.2304))
//
+rs_a=((w-6u)*(w-15u)/(9u-6u)/(9u-15u)*(7.75609E-06)+(w-6u)*(w-9u)/(15u-6u)/(15u-9u)*(4.65365E-06))
+rs_b=((w-6u)*(w-15u)/(9u-6u)/(9u-15u)*(0.22777492)+(w-6u)*(w-9u)/(15u-6u)/(15u-9u)*(0.136664952))
+rs_c=((w-6u)*(w-15u)/(9u-6u)/(9u-15u)*(0.004655002)+(w-6u)*(w-9u)/(15u-6u)/(15u-9u)*(0.002793001))
+rs_d=((w-6u)*(w-15u)/(9u-6u)/(9u-15u)*(0.141680458)+(w-6u)*(w-9u)/(15u-6u)/(15u-9u)*(0.085008275))
+rs_e=((w-6u)*(w-15u)/(9u-6u)/(9u-15u)*(-0.345424039)+(w-6u)*(w-9u)/(15u-6u)/(15u-9u)*(-0.303254423))
//
+ls_a=((w-6u)*(w-15u)/(9u-6u)/(9u-15u)*(10.73727659)+(w-6u)*(w-9u)/(15u-6u)/(15u-9u)*(16.77187369))
+ls_b=((w-6u)*(w-15u)/(9u-6u)/(9u-15u)*(0.267266877)+(w-6u)*(w-9u)/(15u-6u)/(15u-9u)*(0.205407639))
+ls_c=((w-6u)*(w-15u)/(9u-6u)/(9u-15u)*(0.104275199)+(w-6u)*(w-9u)/(15u-6u)/(15u-9u)*(0.068539016))
+ls_d=((w-6u)*(w-15u)/(9u-6u)/(9u-15u)*(-0.107910008)+(w-6u)*(w-9u)/(15u-6u)/(15u-9u)*(-0.071972792))
+ls_e=((w-6u)*(w-15u)/(9u-6u)/(9u-15u)*(-194.3280388)+(w-6u)*(w-9u)/(15u-6u)/(15u-9u)*(-655.2555978))
+ls_f=((w-6u)*(w-15u)/(9u-6u)/(9u-15u)*(0.013998487)+(w-6u)*(w-9u)/(15u-6u)/(15u-9u)*(0.005029712))
+ls_g=((w-6u)*(w-15u)/(9u-6u)/(9u-15u)*(183.9159828)+(w-6u)*(w-9u)/(15u-6u)/(15u-9u)*(638.929009))
//
+cox_a=((w-6u)*(w-15u)/(9u-6u)/(9u-15u)*(0.023460082)+(w-6u)*(w-9u)/(15u-6u)/(15u-9u)*(0.039100136))
+cox_b=((w-6u)*(w-15u)/(9u-6u)/(9u-15u)*(6.271136653)+(w-6u)*(w-9u)/(15u-6u)/(15u-9u)*(10.45189442))
//
+rsub_a=((w-6u)*(w-15u)/(9u-6u)/(9u-15u)*(88352.98446)+(w-6u)*(w-9u)/(15u-6u)/(15u-9u)*(53011.79068))
+rsub_b=((w-6u)*(w-15u)/(9u-6u)/(9u-15u)*(75193.48724)+(w-6u)*(w-9u)/(15u-6u)/(15u-9u)*(45116.09234))
+rsub_c=((w-6u)*(w-15u)/(9u-6u)/(9u-15u)*(2778.049752)+(w-6u)*(w-9u)/(15u-6u)/(15u-9u)*(1666.829851))
+rsub_d=((w-6u)*(w-15u)/(9u-6u)/(9u-15u)*(-658.4666447)+(w-6u)*(w-9u)/(15u-6u)/(15u-9u)*(-395.0799868))
//
+rct_a=((w-6u)*(w-15u)/(9u-6u)/(9u-15u)*(0.125)+(w-6u)*(w-9u)/(15u-6u)/(15u-9u)*(0.075))
+rct_b=((w-6u)*(w-15u)/(9u-6u)/(9u-15u)*(1.075)+(w-6u)*(w-9u)/(15u-6u)/(15u-9u)*(0.645))
//
+lct_a=((w-6u)*(w-15u)/(9u-6u)/(9u-15u)*(0.000394 )+(w-6u)*(w-9u)/(15u-6u)/(15u-9u)*(0.000375 ))
+lct_b=((w-6u)*(w-15u)/(9u-6u)/(9u-15u)*(0)+(w-6u)*(w-9u)/(15u-6u)/(15u-9u)*(0))
+lct_c=((w-6u)*(w-15u)/(9u-6u)/(9u-15u)*(0.190706)+(w-6u)*(w-9u)/(15u-6u)/(15u-9u)*(0.181625))
//
+cox_1=cox_a*nr*da+cox_b
+cox_2=cox_a*nr*da+cox_b
//
+rsub_1=(rsub_a/(nr*da)+rsub_b/da+rsub_c/nr+rsub_d)*(0.000027*(temp-25)*(temp-25)+0.00644586*(temp-25)+1)
+rsub_2=(rsub_a/(nr*da)+rsub_b/da+rsub_c/nr+rsub_d)*(0.000027*(temp-25)*(temp-25)+0.00644586*(temp-25)+1)
//
+csub_1=1.05315e-11/rsub_1
+csub_2=1.05315e-11/rsub_2
//
c12 ( top bottom ) capacitor c=(c12_a*nr+c12_b*nr*da+c12_c*nr*nr+c12_d*da*da+c12_e)*1e-15*c12_indfac

r1 ( top n1 ) resistor r=(r1_a*nr*da*da+r1_b*nr+r1_c*da+r1_d*nr*nr+r1_e)*(0.00328591*(temp-25)+1)*rm6_indfac
l1 ( n1 n3 ) inductor l=(l1_a*nr**(l1_b)*da**(l1_c)*do**(l1_d)+l1_e*nr**(l1_f)+l1_g)*1.0e-9 * l_indfac
l2 ( n3 n2 ) inductor l=(l1_a*nr**(l1_b)*da**(l1_c)*do**(l1_d)+l1_e*nr**(l1_f)+l1_g)*1.0e-9 * l_indfac
r2 ( n2 bottom) resistor r=(r1_a*nr*da*da+r1_b*nr+r1_c*da+r1_d*nr*nr+r1_e)*(0.00328591*(temp-25)+1)*rm6_indfac

ml1 mutual_inductor coupling=(m_a*nr**(m_b)*da**(m_c)*do**(m_d)+m_e*nr**(m_f)+m_g) * k_indfac ind1=l1 ind2=l2

rs1 ( top n11 ) resistor r=(rs_a*nr*da*da+rs_b*nr+rs_c*da+rs_d*nr*nr+rs_e)*(0.00328591*(temp-25)+1)*rsm6_indfac
ls1 ( n11 n1 ) inductor l= (ls_a*nr**(ls_b)*da**(ls_c)*do**(ls_d)+ls_e*nr**(ls_f)+ls_g)*1e-9 * lsm6_indfac
ls2 ( n22 n2 ) inductor l= (ls_a*nr**(ls_b)*da**(ls_c)*do**(ls_d)+ls_e*nr**(ls_f)+ls_g)*1e-9 * lsm6_indfac
rs2 ( n22 bottom ) resistor r=(rs_a*nr*da*da+rs_b*nr+rs_c*da+rs_d*nr*nr+rs_e)*(0.00328591*(temp-25)+1)*rsm6_indfac

cox1 ( top sub1 ) capacitor c=(cox_1)*((1/(7.67792+(4.14167)*(lay-2)))/(0.0412463))*1e-15 * cm6_indfac
cox2 ( bottom sub2 ) capacitor c=(cox_2)*((1/(7.67792+(4.14167)*(lay-2)))/(0.0412463))*1e-15 * cm6_indfac
cox3 ( n3 sub3 ) capacitor c=(cox_1+cox_2)*((1/(7.67792+(4.14167)*(lay-2)))/(0.0412463))*1e-15 * cm6_indfac

csub1 ( sub1 gnode ) capacitor c=(csub_1) * csub_indfac
csub2 ( sub2 gnode ) capacitor c=(csub_2) * csub_indfac
csub3 ( sub3 gnode ) capacitor c=(csub_1+csub_2) * csub_indfac
rsub1 ( sub1 gnode ) resistor r=(rsub_1)*rsub_indfac
rsub2 ( sub2 gnode ) resistor r=(rsub_2)*rsub_indfac
rsub3 ( sub3 gnode ) resistor r=(rsub_1*rsub_2/(rsub_1+rsub_2))*rsub_indfac

rct ( n3 n4 ) resistor r=(rct_a*nr+rct_b)*(0.00328591*(temp-25)+1)*rm5_indfac
lct ( n4 tap ) inductor l=(lct_a*nr*nr+lct_b*nr+lct_c)*1e-9 * lm5_indfac

ends spiral_s2_sym_ct

subckt spiral_s3_sym_ct ( top bottom gnode tap )
parameters nr=3 rad=60u w=30u lay=6
+di=2*rad*1e6
+do=2*rad*1e6+2*(nr*(w*1e6+3)-3)
+da=(di+do)/2
//
+c12_a=((w-6u)*(w-9u)/(30u-6u)/(30u-9u)*(10.00435358))
+c12_b=((w-6u)*(w-9u)/(30u-6u)/(30u-9u)*(0.111537616))
+c12_c=((w-6u)*(w-9u)/(30u-6u)/(30u-9u)*(-1.369840122))
+c12_d=((w-6u)*(w-9u)/(30u-6u)/(30u-9u)*(-0.000139208))
+c12_e=((w-6u)*(w-9u)/(30u-6u)/(30u-9u)*(-22.49856825))
//
+r1_a=((w-6u)*(w-9u)/(30u-6u)/(30u-9u)*(1.0841E-06))
+r1_b=((w-6u)*(w-9u)/(30u-6u)/(30u-9u)*(-0.048048881))
+r1_c=((w-6u)*(w-9u)/(30u-6u)/(30u-9u)*(6.83388E-05))
+r1_d=((w-6u)*(w-9u)/(30u-6u)/(30u-9u)*(0.101386734))
+r1_e=((w-6u)*(w-9u)/(30u-6u)/(30u-9u)*(0.451179252))
//
+l1_a=((w-6u)*(w-9u)/(30u-6u)/(30u-9u)*(0.000405963))
+l1_b=((w-6u)*(w-9u)/(30u-6u)/(30u-9u)*(1.492874307))
+l1_c=((w-6u)*(w-9u)/(30u-6u)/(30u-9u)*(1.866776963))
+l1_d=((w-6u)*(w-9u)/(30u-6u)/(30u-9u)*(-0.720186949))
+l1_e=((w-6u)*(w-9u)/(30u-6u)/(30u-9u)*(5.08362553))
+l1_f=((w-6u)*(w-9u)/(30u-6u)/(30u-9u)*(-0.009655841))
+l1_g=((w-6u)*(w-9u)/(30u-6u)/(30u-9u)*(-5.062355478))
//
+m_a=((w-6u)*(w-9u)/(30u-6u)/(30u-9u)*(0.905447014))
+m_b=((w-6u)*(w-9u)/(30u-6u)/(30u-9u)*(1.261301827))
+m_c=((w-6u)*(w-9u)/(30u-6u)/(30u-9u)*(4.20674721))
+m_d=((w-6u)*(w-9u)/(30u-6u)/(30u-9u)*(-4.477699893))
+m_e=((w-6u)*(w-9u)/(30u-6u)/(30u-9u)*(0.136190791))
+m_f=((w-6u)*(w-9u)/(30u-6u)/(30u-9u)*(0.76704561))
+m_g=((w-6u)*(w-9u)/(30u-6u)/(30u-9u)*(-0.240172913))
//
+rs_a=((w-6u)*(w-9u)/(30u-6u)/(30u-9u)*(2.32683E-06))
+rs_b=((w-6u)*(w-9u)/(30u-6u)/(30u-9u)*(0.068332476))
+rs_c=((w-6u)*(w-9u)/(30u-6u)/(30u-9u)*(0.001396501))
+rs_d=((w-6u)*(w-9u)/(30u-6u)/(30u-9u)*(0.042504137))
+rs_e=((w-6u)*(w-9u)/(30u-6u)/(30u-9u)*(-0.151627212))
//
+ls_a=((w-6u)*(w-9u)/(30u-6u)/(30u-9u)*(-2.991172483))
+ls_b=((w-6u)*(w-9u)/(30u-6u)/(30u-9u)*(2.742014108))
+ls_c=((w-6u)*(w-9u)/(30u-6u)/(30u-9u)*(0.545707143))
+ls_d=((w-6u)*(w-9u)/(30u-6u)/(30u-9u)*(-0.852820095))
+ls_e=((w-6u)*(w-9u)/(30u-6u)/(30u-9u)*(0.650076602))
+ls_f=((w-6u)*(w-9u)/(30u-6u)/(30u-9u)*(2.399142092))
+ls_g=((w-6u)*(w-9u)/(30u-6u)/(30u-9u)*(-0.087336698))
//
+cox_a=((w-6u)*(w-9u)/(30u-6u)/(30u-9u)*(0.062560218))
+cox_b=((w-6u)*(w-9u)/(30u-6u)/(30u-9u)*(16.72303108))
//
+rsub_a=((w-6u)*(w-9u)/(30u-6u)/(30u-9u)*(26505.89534))
+rsub_b=((w-6u)*(w-9u)/(30u-6u)/(30u-9u)*(22558.04617))
+rsub_c=((w-6u)*(w-9u)/(30u-6u)/(30u-9u)*(833.4149256))
+rsub_d=((w-6u)*(w-9u)/(30u-6u)/(30u-9u)*(-97.53999341))
//
+rct_a=((w-6u)*(w-9u)/(30u-6u)/(30u-9u)*(0.1))
+rct_b=((w-6u)*(w-9u)/(30u-6u)/(30u-9u)*(0.311))
//
+lct_a=((w-6u)*(w-9u)/(30u-6u)/(30u-9u)*(0.000250))
+lct_b=((w-6u)*(w-9u)/(30u-6u)/(30u-9u)*(0.002000))
+lct_c=((w-6u)*(w-9u)/(30u-6u)/(30u-9u)*(0.16975))
//
+cox_1=cox_a*nr*da+cox_b
+cox_2=cox_a*nr*da+cox_b
//
+rsub_1=(rsub_a/(nr*da)+rsub_b/da+rsub_c/nr+rsub_d)*(0.000027*(temp-25)*(temp-25)+0.00644586*(temp-25)+1)
+rsub_2=(rsub_a/(nr*da)+rsub_b/da+rsub_c/nr+rsub_d)*(0.000027*(temp-25)*(temp-25)+0.00644586*(temp-25)+1)
//
+csub_1=1.05315e-11/rsub_1
+csub_2=1.05315e-11/rsub_2
//
c12 ( top bottom ) capacitor c=(c12_a*nr+c12_b*nr*da+c12_c*nr*nr+c12_d*da*da+c12_e)*1e-15*c12_indfac

r1 ( top n1 ) resistor r=(r1_a*nr*da*da+r1_b*nr+r1_c*da+r1_d*nr*nr+r1_e)*(0.00328591*(temp-25)+1)*rm6_indfac
l1 ( n1 n3 ) inductor l=(l1_a*nr**(l1_b)*da**(l1_c)*do**(l1_d)+l1_e*nr**(l1_f)+l1_g)*1.0e-9 * l_indfac
l2 ( n3 n2 ) inductor l=(l1_a*nr**(l1_b)*da**(l1_c)*do**(l1_d)+l1_e*nr**(l1_f)+l1_g)*1.0e-9 * l_indfac
r2 ( n2 bottom) resistor r=(r1_a*nr*da*da+r1_b*nr+r1_c*da+r1_d*nr*nr+r1_e)*(0.00328591*(temp-25)+1)*rm6_indfac

ml1 mutual_inductor coupling=(m_a*nr**(m_b)*da**(m_c)*do**(m_d)+m_e*nr**(m_f)+m_g) * k_indfac ind1=l1 ind2=l2

rs1 ( top n11 ) resistor r=(rs_a*nr*da*da+rs_b*nr+rs_c*da+rs_d*nr*nr+rs_e)*(0.00328591*(temp-25)+1)*rsm6_indfac
ls1 ( n11 n1 ) inductor l= (ls_a*nr**(ls_b)*da**(ls_c)*do**(ls_d)+ls_e*nr**(ls_f)+ls_g)*1e-9 * lsm6_indfac
ls2 ( n22 n2 ) inductor l= (ls_a*nr**(ls_b)*da**(ls_c)*do**(ls_d)+ls_e*nr**(ls_f)+ls_g)*1e-9 * lsm6_indfac
rs2 ( n22 bottom ) resistor r=(rs_a*nr*da*da+rs_b*nr+rs_c*da+rs_d*nr*nr+rs_e)*(0.00328591*(temp-25)+1)*rsm6_indfac

cox1 ( top sub1 ) capacitor c=(cox_1)*((1/(7.67792+(4.14167)*(lay-2)))/(0.0412463))*1e-15 * cm6_indfac
cox2 ( bottom sub2 ) capacitor c=(cox_2)*((1/(7.67792+(4.14167)*(lay-2)))/(0.0412463))*1e-15 * cm6_indfac
cox3 ( n3 sub3 ) capacitor c=(cox_1+cox_2)*((1/(7.67792+(4.14167)*(lay-2)))/(0.0412463))*1e-15 * cm6_indfac

csub1 ( sub1 gnode ) capacitor c=(csub_1) * csub_indfac
csub2 ( sub2 gnode ) capacitor c=(csub_2) * csub_indfac
csub3 ( sub3 gnode ) capacitor c=(csub_1+csub_2) * csub_indfac
rsub1 ( sub1 gnode ) resistor r=(rsub_1)*rsub_indfac
rsub2 ( sub2 gnode ) resistor r=(rsub_2)*rsub_indfac
rsub3 ( sub3 gnode ) resistor r=(rsub_1*rsub_2/(rsub_1+rsub_2))*rsub_indfac

rct ( n3 n4 ) resistor r=(rct_a*nr+rct_b)*(0.00328591*(temp-25)+1)*rm5_indfac
lct ( n4 tap ) inductor l=(lct_a*nr*nr+lct_b*nr+lct_c)*1e-9 * lm5_indfac

ends spiral_s3_sym_ct

endsection rf_ind

section rf_mvar
//  **************************************************************************
//  MOS VARACTOR MODEL :
//
//
//   HSPICE LEVEL 49:
//
//      ## library files:
//
//
//       -----------------------------------------------------
//        Model name      L(um)     Group   Branch   Unit Cell
//        -----------------------------------------------------
//         moscap_rf       0.5      1   8   10  50      24
//         moscap_rf33     0.5      1   8   10  50      24
//        -----------------------------------------------------
//       -----------------------------------------------------
//  *************************************************************************
subckt moscap_rf ( gate bulk gnode )
parameters b=25 g=4
+ dt=temp - 25
+ cgmin=((0.3055*b+0.0226)*g+0.04)*1.0e-14*(1+1.449e-4*dt+2.589e-7*(pow(dt,2))) * cmv_fac
+ dcg=((0.388*b-0.14)*g+0.08)*1.0e-14*(1-1.453e-4*dt+1.762e-8*(pow(dt,2))) * cmv_fac
+ dvgs= -0.08697*(1+3.484e-4*dt)
+ vgnorm=0.38*(1+1.053e-3*dt) area=(1.04*b+2.54)*(3.12*g+1.38)*1.0e-12
+ peri=(2*(1.04*b+2.54)+2*(3.12*g+1.38))*1.0e-6
lgate ( gate 3 ) inductor l=(((6.8102/b)-0.9093)*g+46.312)*1.0e-12*l_mvfac
rgate ( 3 4 ) resistor r=((((0.9667/b)+0.0189)*g)+(2.6294/b)+0.2826)*rnpolys_mvfac tc1=4.963e-3 tc2=-5.684e-6
cpar ( 4 5 ) capacitor c=1.507427*b*g*1.0e-15*cmv_fac tc1=1.449e-4 tc2=2.589e-7
cgate ( 4 5 ) bsource q=(cgmin+dcg)*v(4, 5)+vgnorm*dcg*log(cosh((v(4,5)-dvgs)/vgnorm))
rsd ( 5 9 ) resistor r=((((-16.648/b)-0.3366)/(g*g))+(((49.102/b)+0.9459)/g)-(4.8613/b)+0.3796)*rm1_mvfac tc1=4.963e-3 tc2=-5.684e-6
lsd ( 9 bulk ) inductor l=(((6.8102/b)-0.9093)*g+46.312)*1.0e-12*l_mvfac
dnwpsub ( 6 5 ) mvnwdio area=area perim=peri
csub ( 6 gnode ) capacitor c=(1.91455*((1.04*b+2.54)+(3.12*g+1.38)))*csub_mvfac*1.0e-15
rsub ( 6 gnode ) resistor r=(5500/((1.04*b+2.54)+(3.12*g+1.38)))* rsub_mvfac tc1=9.277e-3 tc2=1.014e-4
ends moscap_rf

subckt moscap_rf33 ( gate bulk gnode )
parameters b=25 g=4
+ dt=temp - 25
+ cgmin=((0.2668 * b + 0.0336) *g + (0.015091 * b - 0.12469)) * 1.0e-14 * (1 + 9.459e-5 * dt + 3.469e-7* (pow(dt,2))) * cmv_fac
+ dcg=((0.201 * b - 0.049) * g + 0.14) * 1.0e-14 * (1 -1.076e-4 * dt - 1.962e-7 * (pow(dt,2))) * cmv_fac
+ dvgs= - 0.1758 * (1 + 1.38e-3 * dt)
+ vgnorm=0.55* (1 + 1.45e-3 * dt) area=(1.04 * b + 2.54) * (3.12 * g + 1.38) * 1.0e-12
+ peri=(2 * (1.04 * b + 2.54) + 2 * (3.12 * g + 1.38)) * 1.0e-6
lgate ( gate 3 ) inductor l=(((6.8102/b)-0.9093)*g+46.312)*1.0e-12*l_mvfac
rgate ( 3 4 ) resistor r=((((0.9667/b)+0.0189)*g)+(2.6294/b)+0.2826)*rnpolys_mvfac tc1=4.963e-3 tc2=-5.684e-6
cpar ( 4 5 ) capacitor c=1.160281 * b * g * 1.0e-15 * cmv_fac tc1=9.459e-5 tc2=3.469e-7
cgate ( 4 5 ) bsource q=(cgmin+dcg)*v(4, 5)+vgnorm*dcg*log(cosh((v(4,5)-dvgs)/vgnorm))
rsd ( 5 9 ) resistor r=((((-16.648/b)-0.3366)/(g*g))+(((49.102/b)+0.9459)/g)-(4.8613/b)+0.3796)*rm1_mvfac tc1=4.963e-3 tc2=-5.684e-6
lsd ( 9 bulk ) inductor l=(((6.8102 / b) - 0.9093) * g + 46.312) * 1.0e-12 * l_mvfac
dnwpsub ( 6 5 ) mvnwdio area=area pj=peri
csub ( 6 gnode ) capacitor c=1.91455 * ((1.04*b + 2.54) + (3.12*g + 1.38)) *csub_mvfac * 1.0e-15
rsub ( 6 gnode ) resistor r=(5500/((1.04*b + 2.54)+(3.12*g + 1.38)))*rsub_mvfac tc1=9.277e-3 tc2=3.603e-5
ends moscap_rf33
include "rf018.scs" section=dio_mvnwdio
endsection rf_mvar

section dio_mvnwdio
model mvnwdio diode
+ level=1                   is=6.50e-7                rs=1.0e-10
+ n=1.03                    bv=14.75                  ibv=1e-3
+ ik=1e20                   //ikr=1e10
+ isw=9.75e-13
+ cj=1.337566e-4*cj_mvfac            pb=0.5846489              mj=0.3883243
+ cjsw=5.333577e-10*cj_mvfac         vj=0.5846489             mjsw=0.2345684
+ tlev=1                    eg=1.17                   xti=3
+ tbv1=9.6e-4               trs=1.125e-3              tlevc=1
+ cta=2.8425e-3             ctp=1.5284e-3             pta=2.819e-3
+ ptp=2.819e-3             tnom=25                   fc=0
+ minr=0.1
endsection dio_mvnwdio

section rf_jvar
//  **************************************************************************
//  JUNCTION VARACTOR MODEL :
//
//   HSPICE LEVEL 49:
//
//      ## library files:
//
//      Model name      L(um)    W(um)   Finger   Unit Cell
//      ---------------------------------------------------
//       xjvar_w40      0.42      40     1  50     7
//       xjvar_nr36     0.42    20  60    36       5
//      ---------------------------------------------------
//  *************************************************************************
subckt xjvar_w40 ( anode cathode gnode )
parameters nr=1
+ area_d1=nr*0.42u*40u peri_d1=2*nr*(0.42u+40u)
+ area_d2=(1.4u*nr+1.42u)*(40u+1u) peri_d2=nr*2.8u+84.84u dt=temp-25
r1 ( anode 1 ) resistor r=(-7.759/(nr*nr*nr)+5.767/(nr*nr)+5.7417/nr+0.4202)*xjrm1_fac*(4e-5*dt*dt+0.0058*dt+1)
l1 ( 1 2 ) inductor l=(-28.1006/(nr*nr)+50.9159/(nr)+59.7158)*1e-12*xjl_fac
d1 ( 2 3 ) jvpdio area=area_d1 pj=peri_d1
l2 ( 3 4 ) inductor l=(-28.1006/(nr*nr)+50.9159/(nr)+59.7158)*1e-12*xjl_fac
r2 ( 4 cathode ) resistor r=(-7.759/(nr*nr*nr)+5.767/(nr*nr)+5.7417/nr+0.4202)*xjrm1_fac*(4e-5*dt*dt+0.0058*dt+1)
d2 ( 30 3 ) jvnwdio area=area_d2 pj=peri_d2
rsub ( 30 gnode ) resistor r=(-1.0647*nr+141.98)*xjrsub_fac
csub ( 30 gnode ) capacitor c=1.053e-11*xjcsub_fac/(-1.0647*nr+141.98)
ends xjvar_w40

subckt xjvar_nr36 ( anode cathode gnode )
parameters w=20u
+ area_d1=36*0.42u*w peri_d1=2*36*(0.42u+w)
+ area_d2=(1.42u*36+1.42u)*(w+1u) peri_d2=2*(1.42u*36+w+1.42u) dt=temp-25
r1 ( anode 1 ) resistor r=(-60u*(w*1e+6)*(w*1e+6)+0.0047*(w*1e+6)+0.4949)*xjrm1_fac*(4e-5*dt*dt+0.0058*dt+1)
l1 ( 1 2 ) inductor l=(-0.2128*(w*1e+6)+69.387)*1e-12*xjl_fac
d1 ( 2 3 ) jvpdio area=area_d1 pj=peri_d1
l2 ( 3 4 ) inductor l=(-0.2128*(w*1e+6)+69.387)*1e-12*xjl_fac
r2 ( 4 cathode ) resistor r=(-60u*(w*1e+6)*(w*1e+6)+0.0047*(w*1e+6)+0.4949)*xjrm1_fac*(4e-5*dt*dt+0.0058*dt+1)
d2 ( 30 3 ) jvnwdio area=area_d2 pj=peri_d2
rsub ( 30 gnode ) resistor r=(-0.5675*(w*1e+6)+126.16)*xjrsub_fac
csub ( 30 gnode ) capacitor c=1.053e-11*xjcsub_fac/(-0.5675*(w*1e+6)+126.16)
ends xjvar_nr36
include "rf018.scs" section=dio_jvpdio
include "rf018.scs" section=dio_jvnwdio
endsection rf_jvar

section dio_jvpdio
model jvpdio diode
+ level=1                   is=2.50e-7                rs=1.0e-10
+ n=1.03                    bv=10.1                   ibv=1e-3
+ isw=4.00e-13              area=7.5e-8               pj=1.1e-3
+ cj=1.121e-3*xjdio_cjfac   vj=0.895226               mj=0.4476
+ cjsw=2.241e-10*xjdio_cjfac                          vjsw=0.6
+ mjsw=0.05                 tlev=1                    eg=1.17
+ xti=3                     tbv1=-1*-8.8e-4           trs=1.2e-4
+ tlevc=1                   cta=9.739001e-4           ctp=4.130718e-4
+ pta=1.572025e-3           ptp=1.572025e-3           tnom=25
+ fc=0                                                ns=1.03
+ nz=1.03                   imax=1e40                 minr=1e-10
+ allow_scaling=1
endsection dio_jvpdio

section dio_jvnwdio
model jvnwdio diode
+ level=1                   is=6.50e-7                rs=1.0e-10
+ n=1.03                    bv=14.75                  ibv=1e-3
+ isw=9.75e-13              area=7.5e-8               pj=1.1e-3
+ cj=1.337566e-4*xjcsub_fac vj=0.5846489              mj=0.3883243
+ cjsw=5.333577e-10*xjcsub_fac                        vjsw=0.5846489
+ mjsw=0.2345684            tlev=1                    eg=1.17
+ xti=3                     tbv1=-1*-9.6e-4           trs=1.125e-3
+ tlevc=1                   cta=2.8425e-3             ctp=1.5284e-3
+ pta=2.819e-3              ptp=2.819e-3              tnom=25
+ fc=0                                                ns=1.03
+ nz=1.03                   imax=1e40                 minr=1e-10
+ allow_scaling=1
endsection dio_jvnwdio

//  ************************************************************************************************
//	RESISTOR MODEL - Spectre
//
//      	Model name
// ----------------------------------------------------------------------
// rppoly_rf       P+Poly w/i silicide  0.18um<=W<=5um, 0.25um<=L<=100um, 1<=sqr<=20
// rppolywo_rf	   P+Poly w/o silicide  1um<=W<=5um,    2um<=L<=15um,     2<=sqr<5
// rppolyhri_rf    P-Poly w/o silicide  1um<=W<=5um,    2um<=L<=6.8um,    2<=sqr<5
//
//  ************************************************************************************************

section rf_res_sa
subckt rppoly_rf ( hi lo gnode )
parameters l=1u w=1u mf=1 rsh=rppoly dw=-0.025u
+ ptc1=2.88e-3 ptc2=5.01e-7
+ pvc1=-7.89e-4 pvc2=6.19e-3
+ pt=temp
+ tfac=1.0+ptc1*(pt-25.0)+ptc2*(pt-25.0)*(pt-25.0)
rend1 ( hi 1 ) resistor r=7.8/(int(abs((w-0.42u)/0.47u)+1))/mf
ls1 ( 1 12 ) inductor l=0.033*l*1e+6*(log(l/w)+0.022*w/l+1.19)*1e-12*sal_fac/mf
r1 ( 12 2 ) bsource r=rsh/mf*l/(w-dw)*(1+pvc1*abs(v(12,2))+pvc2*v(12,2)*v(12,2))*tfac/6
ls2 ( 2 23 ) inductor l=2*0.033*l*1e+6*(log(l/w)+0.022*w/l+1.19)*1e-12*sal_fac/mf
r2 ( 23 3 ) bsource r=rsh/mf*l/(w-dw)*(1+pvc1*abs(v(23,3))+pvc2*v(23,3)*v(23,3))*tfac/3
ls4 ( 3 34 ) inductor l=2*0.033*l*1e+6 * (log(l/w)+0.022*w/l+1.19)*1e-12*sal_fac/mf
r4 ( 34 4 ) bsource r=rsh/mf*l/(w-dw)*(1+pvc1*abs(v(34,4))+pvc2*v(34,4)*v(34,4))*tfac/ 3
r3 ( 4 45 ) bsource r=rsh/mf*l/(w-dw)*(1+pvc1* abs(v(4,45))+pvc2*v(4,45)*v(4,45))*tfac/6
ls3 ( 45 5 ) inductor l=0.033*l*1e+6*(log(l/w)+ 0.022*w/l+1.19)*1e-12*sal_fac/ mf
rend2 ( 5 lo ) resistor r=7.8/(int(abs((w-0.42u)/0.47u)+1))/ mf
cox1 ( 2 gnode ) capacitor c=(0.0136*w*(l+1.08u)*1e+12+0.0635*2*(w+l+1.08u)*1e+6+0.0332)*1e-15*sacox_fac*mf
cox2 ( 3 gnode ) capacitor c=(0.0136*w*(l+1.08u)*1e+12+0.0635*2*(w+l+1.08u)*1e+6+0.0332)*1e-15*sacox_fac*mf
cox3 ( 4 gnode ) capacitor c=(0.0136*w*(l+1.08u)*1e+12+0.0635*2*(w+l+1.08u)*1e+6+0.0332)*1e-15*sacox_fac*mf
ends rppoly_rf

endsection rf_res_sa

section rf_res_rpo
subckt rppolywo_rf ( hi lo gnode )
parameters l=1u w=1u mf=1 rend0=7.2135e-5 rsh=rppolyrpo dl=0.0006e-6 dw=0.06165e-6
+ pt=temp
+ pvce1=-0.0145 pvce2=62.8187 pvce3=-2.2165
+ ptce1=-1.692e-3 ptce2=-9.616e-6
+ pvcp1=-0.0011 pvcp2=3.2532e-5 pvcp3=-4.3249
+ ptcp1=-7.541e-5 ptcp2=3.561e-7
+ tface=1.0+ptce1*(pt-25.0)+ptce2*(pt-25.0)*(pt-25.0)
+ tfacp=1.0+ptcp1*(pt-25.0)+ptcp2*(pt-25.0)*(pt-25.0)
rend1 ( hi 1 ) bsource r=(rend0/mf/(w-dw)*tface*(1+pvce1*(tanh(pvce2*abs(v(hi,1))+pvce3)-tanh(pvce3))))
ls1 ( 1 12 ) inductor l=0.033*l*1e+6*(log(l/w)+0.022*w/l+1.19)*1e-12*rpol_fac/mf
r1 ( 12 2 ) bsource r=rsh/mf*(l-dl)/(w-dw)*tfacp*(1+pvcp1*(tanh(pvcp2*abs(v(12,2)/(l-dl))+pvcp3)-tanh(pvcp3)))/6
ls2 ( 2 23 ) inductor l=2*0.033*l*1e+6*(log(l/w)+0.022*w/l+1.19)*1e-12*rpol_fac/mf
r2 ( 23 3 ) bsource r=rsh/mf*(l-dl)/(w-dw)*tfacp*(1+pvcp1*(tanh(pvcp2*abs(v(23,3)/(l-dl))+pvcp3)-tanh(pvcp3)))/3
ls4 ( 3 34 ) inductor l=2*0.033*l*1e+6*(log(l/w)+0.022*w/l+1.19)*1e-12*rpol_fac/mf
r4 ( 34 4 ) bsource r=rsh/mf*(l-dl)/(w-dw)*tfacp*(1+pvcp1*(tanh(pvcp2*abs(v(34,4)/(l-dl))+pvcp3)-tanh(pvcp3)))/3
r3 ( 4 45 ) bsource r=rsh/mf*(l-dl)/(w-dw)*tfacp*(1+pvcp1*(tanh(pvcp2*abs(v(4,45)/(l-dl))+pvcp3)-tanh(pvcp3)))/6
ls3 ( 45 5 ) inductor l=0.033*l*1e+6*(log(l/w)+0.022*w/l+1.19)*1e-12*rpol_fac/mf
rend2 ( 5 lo ) bsource r=(rend0/mf/(w-dw)*tface*(1+pvce1*(tanh(pvce2*abs(v(5,lo))+pvce3)-tanh(pvce3))))
cox1 ( 2 gnode ) capacitor c=(0.0136*w*(l+1.08u)*1e+12+0.0635*2*(w+l+1.08u)*1e+6+0.0332)*1e-15*rpocox_fac*mf
cox2 ( 3 gnode ) capacitor c=(0.0136*w*(l+1.08u)*1e+12+0.0635*2*(w+l+1.08u)*1e+6+0.0332)*1e-15*rpocox_fac*mf
cox3 ( 4 gnode ) capacitor c=(0.0136*w*(l+1.08u)*1e+12+0.0635*2*(w+l+1.08u)*1e+6+0.0332)*1e-15*rpocox_fac*mf
ends rppolywo_rf

endsection rf_res_rpo

section rf_res_hri
subckt rppolyhri_rf ( hi lo gnode )
parameters l=1u w=1u mf=1 rend0=4.944e-005 rsh=rppolyhri dl=0.145e-007 dw=7.382e-008
+ pt=temp
+ pvce1=-2.909e-001 pvce2=-3.902e+001 pvce3=8.339e-001
+ ptce1=-2.335e-003 ptce2=3.933e-006
+ pvcp1=-6.353e-002 pvcp2=2.979e-006 pvcp3=-1.486e+000
+ ptcp1=-1.112e-003 ptcp2=2.775e-006
+ tface=1.0+ptce1*(pt-25.0)+ptce2*(pt-25.0)*(pt-25.0)
+ tfacp=1.0+ptcp1*(pt-25.0)+ptcp2*(pt-25.0)*(pt-25.0)
rend1 ( hi 1 ) bsource r=rend0/mf/(w-dw)*tface*(1+pvce1*(tanh(pvce2*abs(v(hi,1))+pvce3)-tanh(pvce3)))
r1 ( 1 2 ) bsource r=rsh/mf*(l-dl)/(w-dw)*tfacp*(1+pvcp1*(tanh(pvcp2*abs(v(1,2)/(l-dl))+pvcp3)-tanh(pvcp3)))/6
r2 ( 2 3 ) bsource r=rsh/mf*(l-dl)/(w-dw)*tfacp*(1+pvcp1*(tanh(pvcp2*abs(v(2,3)/(l-dl))+pvcp3)-tanh(pvcp3)))/3
r4 ( 3 4 ) bsource r=rsh/mf*(l-dl)/(w-dw)*tfacp*(1+pvcp1*(tanh(pvcp2*abs(v(3,4)/(l-dl))+pvcp3)-tanh(pvcp3)))/3
r3 ( 4 5 ) bsource r=rsh/mf*(l-dl)/(w-dw)*tfacp*(1+pvcp1*(tanh(pvcp2*abs(v(4,5)/(l-dl))+pvcp3)-tanh(pvcp3)))/6
rend2 ( 5 lo ) bsource r=rend0/mf/(w-dw)*tface*(1+pvce1*(tanh(pvce2*abs(v(5,lo))+pvce3)-tanh(pvce3)))
cox1 ( 2 gnode ) capacitor c=(0.0136*w*(l+1.08u)*1e+12+0.0635*2*(w+l+1.08u)*1e+6+0.0332)*1e-15*hricox_fac*mf
cox2 ( 3 gnode ) capacitor c=(0.0136*w*(l+1.08u)*1e+12+0.0635*2*(w+l+1.08u)*1e+6+0.0332)*1e-15*hricox_fac*mf
cox3 ( 4 gnode ) capacitor c=(0.0136*w*(l+1.08u)*1e+12+0.0635*2*(w+l+1.08u)*1e+6+0.0332)*1e-15*hricox_fac*mf
ends rppolyhri_rf

endsection rf_res_hri

section rf_esd
//  ************************************************************************************************
// 	ESD MODEL - HSPICE
//
//       	Model name	Description
//
//    	----------------------------------------------
// 	lcesd1_rf		desinged for about 50fF
// 	lcesd2_rf		desinged for about 100fF
//      ----------------------------------------------
//
//  ************************************************************************************************

subckt lcesd1_rf ( plus minus )
r1 ( plus 1 ) resistor r=2.0 * rm1_esdfac
c1 ( 1 minus ) capacitor c=7f
d1 ( 2 1 ) nwdio_esd area=40p pj=28u m=1
rsub1 ( 2 minus ) resistor r=185 * rsub_esdfac
csub1 ( 2 minus ) capacitor c=29.5f * csub_esdfac
d2 ( 1 3 ) pdio_esd area=25.4p pj=27.66u
d3 ( 4 3 ) nwdio_esd area=38.09p pj=31.14u
rsub2 ( 4 minus ) resistor r=353 * rsub_esdfac
csub2 ( 4 minus ) capacitor c=15.4f * csub_esdfac
r2 ( 1 5 ) resistor r=14.19 * rpodrpo_esdfac
d4 ( 6 5 ) ndiof_esd area=8.95p pj=8.58u
d5 ( 6 5 ) ndiog_esd area=1f pj=5u
rsub3 ( 6 minus ) resistor r=96.5 * rsub_esdfac
csub3 ( 6 minus ) capacitor c=0.52f * csub_esdfac

ends lcesd1_rf

subckt lcesd2_rf ( plus minus )
r1 ( plus 1 ) resistor r=2.0 * rm1_esdfac
c1 ( 1 minus ) capacitor c=7f
d1 ( 2 1 ) nwdio_esd area=39.48p pj=30.32u m=2
rsub1 ( 2 minus ) resistor r=92 * rsub_esdfac
csub1 ( 2 minus ) capacitor c=59.1f * csub_esdfac
d2 ( 1 3 ) pdio_esd area=54.63p pj=44.86u
d3 ( 4 3 ) nwdio_esd area=74.73p pj=48.34u
rsub2 ( 4 minus ) resistor r=228 * rsub_esdfac
csub2 ( 4 minus ) capacitor c=23.8f * csub_esdfac
r2 ( 1 5 ) resistor r=12.74 * rpodrpo_esdfac
d4 ( 6 5 ) ndiof_esd area=8.95p pj=8.58u m=2
d5 ( 6 5 ) ndiog_esd area=1f pj=5u m=2
rsub3 ( 6 minus ) resistor r=48.3 * rsub_esdfac
csub3 ( 6 minus ) capacitor c=1.04f * csub_esdfac

ends lcesd2_rf

include "rf018.scs" section=dio_rfesd
endsection rf_esd

section dio_rfesd
//  *************************************************************
//          MODEL OF P+/NW RF DIODE                       *
//  *************************************************************
model pdio_esd diode
+ level=1                   is=2.50e-7
+ n=1.03                    bv=10.1                   ibv=1e-3
+ isw=4.00e-13              area=7.5e-8               pj=1.1e-3
+ cj=1.121e-3*cj_esdfac     vj=0.895226               mj=0.4476
+ cjsw=2.481e-10*cj_esdfac  vjsw=0.895226             mjsw=0.3683619
+ tlev=1                    eg=1.17                   xti=3
+ tbv1=-1*-8.8e-4           tlevc=1
+ cta=9.739001e-4           ctp=4.130718e-4           pta=1.572025e-3
+ ptp=1.572025e-3           tnom=25                   fc=0
+ ns=1.03                   nz=1.03
+ imax=1e40                 minr=1e-10                allow_scaling=1
//  *************************************************************
//          MODEL OF N+/PW RF DIODE                       *
//  *************************************************************
model ndiof_esd diode
+ level=1                   is=3.50e-7
+ n=1.03                    bv=11.10                  ibv=1e-3
+ isw=4.00e-13              area=7.5e-8               pj=1.1e-3
+ cj=1.000266e-3*cj_esdfac  vj=0.6882682              mj=0.3595262
+ cjsw=2.040547e-10*cj_esdfac                         vjsw=0.6882682
+ mjsw=0.2003879            tlev=1                    eg=1.17
+ xti=3                     tbv1=-1*-9.3e-4
+ tlevc=1                   cta=1.040287e-3           ctp=6.45489e-4
+ pta=1.554306e-3           ptp=1.554306e-3           tnom=25
+ fc=0                      ns=1.03
+ nz=1.03                   imax=1e40                 minr=1e-10
+ allow_scaling=1

model ndiog_esd diode
+ level=1                   is=3.50e-7
+ n=1.03                    bv=11.10                  ibv=1e-3
+ isw=4.00e-13              area=7.5e-8               pj=1.1e-3
+ cj=1.000266e-3*cj_esdfac  vj=0.6882682              mj=0.3595262
+ cjsw=3.340547e-10*cj_esdfac                         vjsw=0.6882682
+ mjsw=0.43879              tlev=1                    eg=1.17
+ xti=3                     tbv1=-1*-9.3e-4
+ tlevc=1                   cta=1.040287e-3           ctp=6.45489e-4
+ pta=1.554306e-3           ptp=1.554306e-3           tnom=25
+ fc=0                      ns=1.03
+ nz=1.03                   imax=1e40                 minr=1e-10
+ allow_scaling=1

//  *************************************************************
//          MODEL OF NW/Psub RF DIODE                    	 *
//  *************************************************************
model nwdio_esd diode
+ level=1                   is=1.55e-5
+ n=1.38                    bv=14.75                  ibv=1e-3
+ isw=4.75e-11              area=7.5e-8               pj=1.1e-3
+ cj=1.337566e-4*csub_esdfac                          vj=0.5846489
+ mj=0.3883243              cjsw=5.333577e-10*csub_esdfac
+ vjsw=0.5846489            mjsw=0.2345684            tlev=1
+ eg=1.17                   xti=3                     tbv1=-1*-9.6e-4
+ tlevc=1                   cta=2.8425e-3
+ ctp=1.5284e-3             pta=2.819e-3              ptp=2.819e-3
+ tnom=25                   fc=0
+ ns=1.38                   nz=1.38                   imax=1e40
+ minr=1e-10                allow_scaling=1
endsection dio_rfesd

//  ****************************************************************************
//                                                                             *
//      BASEBAND model                                                         *
//                                                                             *
//                                                                             *
//  ****************************************************************************
//
//
//
//
//
//
//  ****************************    LIBRARY OF TYPICAL CASE    ******************************
section tt
parameters a1n=0
parameters a1p=0
parameters a2np=0
parameters a3np=0
parameters a4np=0
parameters vthnmis=0
parameters dlnmis=0
parameters dwnmis=0
parameters toxnmis=0
parameters vthpmis=0
parameters dlpmis=0
parameters dwpmis=0
parameters toxpmis=0
parameters fac_n=0.3766 * 2.4
parameters fac_p=0.3766 * 2.1
parameters du0n=a1n * fac_n * ( - 0.2e-2)
parameters dlu0n=a1n * fac_n * ( - 0.5e-9)
parameters dwu0n=a1n * fac_n * ( - 0.00e-9)
parameters dpu0n=a1n * fac_n * ( - 0.0e-16)
parameters dvthn=a1n * fac_n * 0.0205
parameters dlvthn=a1n * fac_n * 2.9e-9
parameters dwvthn=a1n * fac_n * 6.60e-9
parameters dpvthn=a1n * fac_n * 3.0e-15
parameters toxn=4.08e-09 + a4np * fac_n * 1.33e-10 * 0.5
parameters dxln=a2np * fac_n * 1.33e-8 * 0.5
parameters dxwn=a3np * fac_n * 2.2e-8 * 0.5
parameters dk2n=a1n * fac_n * 0.008
parameters dlk2n=a1n * fac_n * 0.4e-8
parameters dvsatn= - a1n * fac_n * 0.4e4
parameters dwvsatn= - a1n * fac_n * 0.0e-3
parameters deta0n=0.0 * a1n * fac_n
parameters dleta0n= - 0.35e-9 * 0.5 * (a1n * fac_n - sqrt(a1n * fac_n * a1n * fac_n
+ + 1e-8))
parameters dweta0n=0
parameters dpeta0n= - 1.5e-16 * 0.5 * (a1n * fac_n - sqrt(a1n * fac_n * a1n * fac_n
+ + 1e-8))
parameters dnfactorn=a1n * fac_n * 0
parameters dlnfactorn=a1n * fac_n * 5e-8
parameters dwnfactorn=a1n * fac_n * 0
parameters dpnfactorn=a1n * fac_n * 0.0e-15
parameters dvoffn= - a1n * fac_n * 0.003
parameters dlvoffn= - a1n * fac_n * 1.0e-9
parameters dwvoffn= - a1n * fac_n * 0.7e-9
parameters dpvoffn= - a1n * fac_n * 1.0e-15
parameters du0p=a1p * fac_p * ( - 0.007e-2)
parameters dlu0p=a1p * fac_p * ( - 0.1e-9)
parameters dwu0p=a1p * fac_p * ( - 0.025e-9)
parameters dpu0p=a1p * fac_p * ( - 0.0e-16)
parameters dvthp=a1p * fac_p * ( - 0.030)
parameters dlvthp=a1p * fac_p * ( - 5.00e-9)
parameters dwvthp=a1p * fac_p * ( - 1.5e-9)
parameters dpvthp=a1p * fac_p * ( - 1.5e-15)
parameters toxp=4.08e-09 + a4np * fac_p * 1.33e-10 * 0.5
parameters dxlp=a2np * fac_p * 1.33e-8 * 0.5
parameters dxwp=a3np * fac_p * 2.2e-8 * 0.5
parameters drdswp=0
parameters dk2p=a1p * fac_p * 0.007
parameters dlk2p=a1p * fac_p * 0.15e-8
parameters dvsatp= - a1p * fac_p * 0.00e4
parameters dwvsatp= - a1p * fac_p * 0.0e-3
parameters deta0p=0
parameters dleta0p= - 6e-10 * 0.5 * (a1p * fac_p - sqrt(a1p * fac_p * a1p * fac_p
+ + 1e-8))
parameters dweta0p=0
parameters dpeta0p= - 0.6e-16 * 0.5 * (a1p * fac_p - sqrt(a1p * fac_p * a1p * fac_p
+ + 1e-8))
parameters dnfactorp=a1p * fac_p * 0
parameters dlnfactorp= - a1p * fac_p * 0.5e-8
parameters dwnfactorp= - a1p * fac_p * 0
parameters dpnfactorp=0
parameters dvoffp= - a1p * fac_p * 0.000
parameters dlvoffp= - a1p * fac_p * 0.2e-8
parameters dwvoffp= - a1p * fac_p * 0.0e-8
parameters dpvoffp= - a1p * fac_p * 0.0e-15
parameters cjn=0.001000266
parameters cjswn=2.040547e-10
parameters cjswgn=3.340547e-10
parameters cgon=3.665e-10
parameters hdifn=2e-07
parameters rshn=6.8
parameters dk1n=0
parameters drdswn=0
parameters cjp=0.001121
parameters cjswp=2.481e-10
parameters cjswgp=4.221e-10
parameters cgop=3.28e-10
parameters hdifp=2e-07
parameters rshp=7.2

statistics {
    mismatch {
        vary vthnmis dist=gauss std=1/1
        vary dlnmis dist=gauss std=1/1
        vary dwnmis dist=gauss std=1/1
        vary toxnmis dist=gauss std=1/1
        vary vthpmis dist=gauss std=1/1
        vary dlpmis dist=gauss std=1/1
        vary dwpmis dist=gauss std=1/1
        vary toxpmis dist=gauss std=1/1
        }
    }
include "rf018.scs" section=mos
endsection tt

//  ****************************  LIBRARY OF SNSP CORNER CASE  ******************************
section ss
parameters a1n=1
parameters a1p=1
parameters a2np=1
parameters a3np=-1
parameters a4np=1
parameters vthnmis=0
parameters dlnmis=0
parameters dwnmis=0
parameters toxnmis=0
parameters vthpmis=0
parameters dlpmis=0
parameters dwpmis=0
parameters toxpmis=0
parameters fac_n=0.3766 * 2.4
parameters fac_p=0.3766 * 2.1
parameters du0n=a1n * fac_n * ( - 0.2e-2)
parameters dlu0n=a1n * fac_n * ( - 0.5e-9)
parameters dwu0n=a1n * fac_n * ( - 0.00e-9)
parameters dpu0n=a1n * fac_n * ( - 0.0e-16)
parameters dvthn=a1n * fac_n * 0.0205
parameters dlvthn=a1n * fac_n * 2.9e-9
parameters dwvthn=a1n * fac_n * 6.60e-9
parameters dpvthn=a1n * fac_n * 3.0e-15
parameters toxn=4.08e-09 + a4np * fac_n * 1.33e-10 * 0.5
parameters dxln=a2np * fac_n * 1.33e-8 * 0.5
parameters dxwn=a3np * fac_n * 2.2e-8 * 0.5
parameters dk2n=a1n * fac_n * 0.008
parameters dlk2n=a1n * fac_n * 0.4e-8
parameters dvsatn= - a1n * fac_n * 0.4e4
parameters dwvsatn= - a1n * fac_n * 0.0e-3
parameters deta0n=0.0 * a1n * fac_n
parameters dleta0n= - 0.35e-9 * 0.5 * (a1n * fac_n - sqrt(a1n * fac_n * a1n * fac_n
+ + 1e-8))
parameters dweta0n=0
parameters dpeta0n= - 1.5e-16 * 0.5 * (a1n * fac_n - sqrt(a1n * fac_n * a1n * fac_n
+ + 1e-8))
parameters dnfactorn=a1n * fac_n * 0
parameters dlnfactorn=a1n * fac_n * 5e-8
parameters dwnfactorn=a1n * fac_n * 0
parameters dpnfactorn=a1n * fac_n * 0.0e-15
parameters dvoffn= - a1n * fac_n * 0.003
parameters dlvoffn= - a1n * fac_n * 1.0e-9
parameters dwvoffn= - a1n * fac_n * 0.7e-9
parameters dpvoffn= - a1n * fac_n * 1.0e-15
parameters du0p=a1p * fac_p * ( - 0.007e-2)
parameters dlu0p=a1p * fac_p * ( - 0.1e-9)
parameters dwu0p=a1p * fac_p * ( - 0.025e-9)
parameters dpu0p=a1p * fac_p * ( - 0.0e-16)
parameters dvthp=a1p * fac_p * ( - 0.030)
parameters dlvthp=a1p * fac_p * ( - 5.00e-9)
parameters dwvthp=a1p * fac_p * ( - 1.5e-9)
parameters dpvthp=a1p * fac_p * ( - 1.5e-15)
parameters toxp=4.08e-09 + a4np * fac_p * 1.33e-10 * 0.5
parameters dxlp=a2np * fac_p * 1.33e-8 * 0.5
parameters dxwp=a3np * fac_p * 2.2e-8 * 0.5
parameters drdswp=0
parameters dk2p=a1p * fac_p * 0.007
parameters dlk2p=a1p * fac_p * 0.15e-8
parameters dvsatp= - a1p * fac_p * 0.00e4
parameters dwvsatp= - a1p * fac_p * 0.0e-3
parameters deta0p=0
parameters dleta0p= - 6e-10 * 0.5 * (a1p * fac_p - sqrt(a1p * fac_p * a1p * fac_p
+ + 1e-8))
parameters dweta0p=0
parameters dpeta0p= - 0.6e-16 * 0.5 * (a1p * fac_p - sqrt(a1p * fac_p * a1p * fac_p
+ + 1e-8))
parameters dnfactorp=a1p * fac_p * 0
parameters dlnfactorp= - a1p * fac_p * 0.5e-8
parameters dwnfactorp= - a1p * fac_p * 0
parameters dpnfactorp=0
parameters dvoffp= - a1p * fac_p * 0.000
parameters dlvoffp= - a1p * fac_p * 0.2e-8
parameters dwvoffp= - a1p * fac_p * 0.0e-8
parameters dpvoffp= - a1p * fac_p * 0.0e-15
parameters cjn=0.001050279
parameters cjswn=2.142574e-10
parameters cjswgn=3.507574e-10
parameters cgon=3.48175e-10
parameters hdifn=2e-07
parameters rshn=6.8
parameters dk1n=0
parameters drdswn=0
parameters cjp=0.00117705
parameters cjswp=2.60505e-10
parameters cjswgp=4.43205e-10
parameters cgop=3.116e-10
parameters hdifp=2e-07
parameters rshp=7.2

statistics {
    mismatch {
        vary vthnmis dist=gauss std=1/1
        vary dlnmis dist=gauss std=1/1
        vary dwnmis dist=gauss std=1/1
        vary toxnmis dist=gauss std=1/1
        vary vthpmis dist=gauss std=1/1
        vary dlpmis dist=gauss std=1/1
        vary dwpmis dist=gauss std=1/1
        vary toxpmis dist=gauss std=1/1
        }
    }

include "rf018.scs" section=mos
endsection ss

//  ****************************  LIBRARY OF FNFP CORNER CASE  ******************************
section ff
parameters a1n=-1
parameters a1p=-1
parameters a2np=-1
parameters a3np=1
parameters a4np=-1
parameters vthnmis=0
parameters dlnmis=0
parameters dwnmis=0
parameters toxnmis=0
parameters vthpmis=0
parameters dlpmis=0
parameters dwpmis=0
parameters toxpmis=0
parameters fac_n=0.3766 * 2.4
parameters fac_p=0.3766 * 2.1
parameters du0n=a1n * fac_n * ( - 0.2e-2)
parameters dlu0n=a1n * fac_n * ( - 0.5e-9)
parameters dwu0n=a1n * fac_n * ( - 0.00e-9)
parameters dpu0n=a1n * fac_n * ( - 0.0e-16)
parameters dvthn=a1n * fac_n * 0.0205
parameters dlvthn=a1n * fac_n * 2.9e-9
parameters dwvthn=a1n * fac_n * 6.60e-9
parameters dpvthn=a1n * fac_n * 3.0e-15
parameters toxn=4.08e-09 + a4np * fac_n * 1.33e-10 * 0.5
parameters dxln=a2np * fac_n * 1.33e-8 * 0.5
parameters dxwn=a3np * fac_n * 2.2e-8 * 0.5
parameters dk2n=a1n * fac_n * 0.008
parameters dlk2n=a1n * fac_n * 0.4e-8
parameters dvsatn= - a1n * fac_n * 0.4e4
parameters dwvsatn= - a1n * fac_n * 0.0e-3
parameters deta0n=0.0 * a1n * fac_n
parameters dleta0n= - 0.35e-9 * 0.5 * (a1n * fac_n - sqrt(a1n * fac_n * a1n * fac_n
+ + 1e-8))
parameters dweta0n=0
parameters dpeta0n= - 1.5e-16 * 0.5 * (a1n * fac_n - sqrt(a1n * fac_n * a1n * fac_n
+ + 1e-8))
parameters dnfactorn=a1n * fac_n * 0
parameters dlnfactorn=a1n * fac_n * 5e-8
parameters dwnfactorn=a1n * fac_n * 0
parameters dpnfactorn=a1n * fac_n * 0.0e-15
parameters dvoffn= - a1n * fac_n * 0.003
parameters dlvoffn= - a1n * fac_n * 1.0e-9
parameters dwvoffn= - a1n * fac_n * 0.7e-9
parameters dpvoffn= - a1n * fac_n * 1.0e-15
parameters du0p=a1p * fac_p * ( - 0.007e-2)
parameters dlu0p=a1p * fac_p * ( - 0.1e-9)
parameters dwu0p=a1p * fac_p * ( - 0.025e-9)
parameters dpu0p=a1p * fac_p * ( - 0.0e-16)
parameters dvthp=a1p * fac_p * ( - 0.030)
parameters dlvthp=a1p * fac_p * ( - 5.00e-9)
parameters dwvthp=a1p * fac_p * ( - 1.5e-9)
parameters dpvthp=a1p * fac_p * ( - 1.5e-15)
parameters toxp=4.08e-09 + a4np * fac_p * 1.33e-10 * 0.5
parameters dxlp=a2np * fac_p * 1.33e-8 * 0.5
parameters dxwp=a3np * fac_p * 2.2e-8 * 0.5
parameters drdswp=0
parameters dk2p=a1p * fac_p * 0.007
parameters dlk2p=a1p * fac_p * 0.15e-8
parameters dvsatp= - a1p * fac_p * 0.00e4
parameters dwvsatp= - a1p * fac_p * 0.0e-3
parameters deta0p=0
parameters dleta0p= - 6e-10 * 0.5 * (a1p * fac_p - sqrt(a1p * fac_p * a1p * fac_p
+ + 1e-8))
parameters dweta0p=0
parameters dpeta0p= - 0.6e-16 * 0.5 * (a1p * fac_p - sqrt(a1p * fac_p * a1p * fac_p
+ + 1e-8))
parameters dnfactorp=a1p * fac_p * 0
parameters dlnfactorp= - a1p * fac_p * 0.5e-8
parameters dwnfactorp= - a1p * fac_p * 0
parameters dpnfactorp=0
parameters dvoffp= - a1p * fac_p * 0.000
parameters dlvoffp= - a1p * fac_p * 0.2e-8
parameters dwvoffp= - a1p * fac_p * 0.0e-8
parameters dpvoffp= - a1p * fac_p * 0.0e-15
parameters cjn=0.0009502527
parameters cjswn=1.93852e-10
parameters cjswgn=3.17352e-10
parameters cgon=3.84825e-10
parameters hdifn=2e-07
parameters rshn=6.8
parameters dk1n=0
parameters drdswn=0
parameters cjp=0.00106495
parameters cjswp=2.35695e-10
parameters cjswgp=4.00995e-10
parameters cgop=3.444e-10
parameters hdifp=2e-07
parameters rshp=7.2

statistics {
    mismatch {
        vary vthnmis dist=gauss std=1/1
        vary dlnmis dist=gauss std=1/1
        vary dwnmis dist=gauss std=1/1
        vary toxnmis dist=gauss std=1/1
        vary vthpmis dist=gauss std=1/1
        vary dlpmis dist=gauss std=1/1
        vary dwpmis dist=gauss std=1/1
        vary toxpmis dist=gauss std=1/1
        }
    }

include "rf018.scs" section=mos
endsection ff

//  ****************************  LIBRARY OF SNFP CORNER CASE  ******************************
section sf
parameters a1n=1
parameters a1p=-1
parameters a2np=0
parameters a3np=0
parameters a4np=0
parameters vthnmis=0
parameters dlnmis=0
parameters dwnmis=0
parameters toxnmis=0
parameters vthpmis=0
parameters dlpmis=0
parameters dwpmis=0
parameters toxpmis=0
parameters fac_n=0.3766 * 2.4
parameters fac_p=0.3766 * 2.1
parameters du0n=a1n * fac_n * ( - 0.2e-2)
parameters dlu0n=a1n * fac_n * ( - 0.5e-9)
parameters dwu0n=a1n * fac_n * ( - 0.00e-9)
parameters dpu0n=a1n * fac_n * ( - 0.0e-16)
parameters dvthn=a1n * fac_n * 0.0205
parameters dlvthn=a1n * fac_n * 2.9e-9
parameters dwvthn=a1n * fac_n * 6.60e-9
parameters dpvthn=a1n * fac_n * 3.0e-15
parameters toxn=4.08e-09 + a4np * fac_n * 1.33e-10 * 0.5
parameters dxln=a2np * fac_n * 1.33e-8 * 0.5
parameters dxwn=a3np * fac_n * 2.2e-8 * 0.5
parameters dk2n=a1n * fac_n * 0.008
parameters dlk2n=a1n * fac_n * 0.4e-8
parameters dvsatn= - a1n * fac_n * 0.4e4
parameters dwvsatn= - a1n * fac_n * 0.0e-3
parameters deta0n=0.0 * a1n * fac_n
parameters dleta0n= - 0.35e-9 * 0.5 * (a1n * fac_n - sqrt(a1n * fac_n * a1n * fac_n
+ + 1e-8))
parameters dweta0n=0
parameters dpeta0n= - 1.5e-16 * 0.5 * (a1n * fac_n - sqrt(a1n * fac_n * a1n * fac_n
+ + 1e-8))
parameters dnfactorn=a1n * fac_n * 0
parameters dlnfactorn=a1n * fac_n * 5e-8
parameters dwnfactorn=a1n * fac_n * 0
parameters dpnfactorn=a1n * fac_n * 0.0e-15
parameters dvoffn= - a1n * fac_n * 0.003
parameters dlvoffn= - a1n * fac_n * 1.0e-9
parameters dwvoffn= - a1n * fac_n * 0.7e-9
parameters dpvoffn= - a1n * fac_n * 1.0e-15
parameters du0p=a1p * fac_p * ( - 0.007e-2)
parameters dlu0p=a1p * fac_p * ( - 0.1e-9)
parameters dwu0p=a1p * fac_p * ( - 0.025e-9)
parameters dpu0p=a1p * fac_p * ( - 0.0e-16)
parameters dvthp=a1p * fac_p * ( - 0.030)
parameters dlvthp=a1p * fac_p * ( - 5.00e-9)
parameters dwvthp=a1p * fac_p * ( - 1.5e-9)
parameters dpvthp=a1p * fac_p * ( - 1.5e-15)
parameters toxp=4.08e-09 + a4np * fac_p * 1.33e-10 * 0.5
parameters dxlp=a2np * fac_p * 1.33e-8 * 0.5
parameters dxwp=a3np * fac_p * 2.2e-8 * 0.5
parameters drdswp=0
parameters dk2p=a1p * fac_p * 0.007
parameters dlk2p=a1p * fac_p * 0.15e-8
parameters dvsatp= - a1p * fac_p * 0.00e4
parameters dwvsatp= - a1p * fac_p * 0.0e-3
parameters deta0p=0
parameters dleta0p= - 6e-10 * 0.5 * (a1p * fac_p - sqrt(a1p * fac_p * a1p * fac_p
+ + 1e-8))
parameters dweta0p=0
parameters dpeta0p= - 0.6e-16 * 0.5 * (a1p * fac_p - sqrt(a1p * fac_p * a1p * fac_p
+ + 1e-8))
parameters dnfactorp=a1p * fac_p * 0
parameters dlnfactorp= - a1p * fac_p * 0.5e-8
parameters dwnfactorp= - a1p * fac_p * 0
parameters dpnfactorp=0
parameters dvoffp= - a1p * fac_p * 0.000
parameters dlvoffp= - a1p * fac_p * 0.2e-8
parameters dwvoffp= - a1p * fac_p * 0.0e-8
parameters dpvoffp= - a1p * fac_p * 0.0e-15
parameters cjn=0.001050279
parameters cjswn=2.142574e-10
parameters cjswgn=3.507574e-10
parameters cgon=3.665e-10
parameters hdifn=2e-07
parameters rshn=6.8
parameters dk1n=0
parameters drdswn=0
parameters cjp=0.00106495
parameters cjswp=2.35695e-10
parameters cjswgp=4.00995e-10
parameters cgop=3.28e-10
parameters hdifp=2e-07
parameters rshp=7.2

statistics {
    mismatch {
        vary vthnmis dist=gauss std=1/1
        vary dlnmis dist=gauss std=1/1
        vary dwnmis dist=gauss std=1/1
        vary toxnmis dist=gauss std=1/1
        vary vthpmis dist=gauss std=1/1
        vary dlpmis dist=gauss std=1/1
        vary dwpmis dist=gauss std=1/1
        vary toxpmis dist=gauss std=1/1
        }
    }

include "rf018.scs" section=mos
endsection sf

//  ****************************  LIBRARY OF FNSP CORNER CASE  ******************************
section fs
parameters a1n=-1
parameters a1p=1
parameters a2np=0
parameters a3np=0
parameters a4np=0
parameters vthnmis=0
parameters dlnmis=0
parameters dwnmis=0
parameters toxnmis=0
parameters vthpmis=0
parameters dlpmis=0
parameters dwpmis=0
parameters toxpmis=0
parameters fac_n=0.3766 * 2.4
parameters fac_p=0.3766 * 2.1
parameters du0n=a1n * fac_n * ( - 0.2e-2)
parameters dlu0n=a1n * fac_n * ( - 0.5e-9)
parameters dwu0n=a1n * fac_n * ( - 0.00e-9)
parameters dpu0n=a1n * fac_n * ( - 0.0e-16)
parameters dvthn=a1n * fac_n * 0.0205
parameters dlvthn=a1n * fac_n * 2.9e-9
parameters dwvthn=a1n * fac_n * 6.60e-9
parameters dpvthn=a1n * fac_n * 3.0e-15
parameters toxn=4.08e-09 + a4np * fac_n * 1.33e-10 * 0.5
parameters dxln=a2np * fac_n * 1.33e-8 * 0.5
parameters dxwn=a3np * fac_n * 2.2e-8 * 0.5
parameters dk2n=a1n * fac_n * 0.008
parameters dlk2n=a1n * fac_n * 0.4e-8
parameters dvsatn= - a1n * fac_n * 0.4e4
parameters dwvsatn= - a1n * fac_n * 0.0e-3
parameters deta0n=0.0 * a1n * fac_n
parameters dleta0n= - 0.35e-9 * 0.5 * (a1n * fac_n - sqrt(a1n * fac_n * a1n * fac_n
+ + 1e-8))
parameters dweta0n=0
parameters dpeta0n= - 1.5e-16 * 0.5 * (a1n * fac_n - sqrt(a1n * fac_n * a1n * fac_n
+ + 1e-8))
parameters dnfactorn=a1n * fac_n * 0
parameters dlnfactorn=a1n * fac_n * 5e-8
parameters dwnfactorn=a1n * fac_n * 0
parameters dpnfactorn=a1n * fac_n * 0.0e-15
parameters dvoffn= - a1n * fac_n * 0.003
parameters dlvoffn= - a1n * fac_n * 1.0e-9
parameters dwvoffn= - a1n * fac_n * 0.7e-9
parameters dpvoffn= - a1n * fac_n * 1.0e-15
parameters du0p=a1p * fac_p * ( - 0.007e-2)
parameters dlu0p=a1p * fac_p * ( - 0.1e-9)
parameters dwu0p=a1p * fac_p * ( - 0.025e-9)
parameters dpu0p=a1p * fac_p * ( - 0.0e-16)
parameters dvthp=a1p * fac_p * ( - 0.030)
parameters dlvthp=a1p * fac_p * ( - 5.00e-9)
parameters dwvthp=a1p * fac_p * ( - 1.5e-9)
parameters dpvthp=a1p * fac_p * ( - 1.5e-15)
parameters toxp=4.08e-09 + a4np * fac_p * 1.33e-10 * 0.5
parameters dxlp=a2np * fac_p * 1.33e-8 * 0.5
parameters dxwp=a3np * fac_p * 2.2e-8 * 0.5
parameters drdswp=0
parameters dk2p=a1p * fac_p * 0.007
parameters dlk2p=a1p * fac_p * 0.15e-8
parameters dvsatp= - a1p * fac_p * 0.00e4
parameters dwvsatp= - a1p * fac_p * 0.0e-3
parameters deta0p=0
parameters dleta0p= - 6e-10 * 0.5 * (a1p * fac_p - sqrt(a1p * fac_p * a1p * fac_p
+ + 1e-8))
parameters dweta0p=0
parameters dpeta0p= - 0.6e-16 * 0.5 * (a1p * fac_p - sqrt(a1p * fac_p * a1p * fac_p
+ + 1e-8))
parameters dnfactorp=a1p * fac_p * 0
parameters dlnfactorp= - a1p * fac_p * 0.5e-8
parameters dwnfactorp= - a1p * fac_p * 0
parameters dpnfactorp=0
parameters dvoffp= - a1p * fac_p * 0.000
parameters dlvoffp= - a1p * fac_p * 0.2e-8
parameters dwvoffp= - a1p * fac_p * 0.0e-8
parameters dpvoffp= - a1p * fac_p * 0.0e-15
parameters cjn=0.0009502527
parameters cjswn=1.93852e-10
parameters cjswgn=3.17352e-10
parameters cgon=3.665e-10
parameters hdifn=2e-07
parameters rshn=6.8
parameters dk1n=0
parameters drdswn=0
parameters cjp=0.00117705
parameters cjswp=2.60505e-10
parameters cjswgp=4.43205e-10
parameters cgop=3.28e-10
parameters hdifp=2e-07
parameters rshp=7.2

statistics {
    mismatch {
        vary vthnmis dist=gauss std=1/1
        vary dlnmis dist=gauss std=1/1
        vary dwnmis dist=gauss std=1/1
        vary toxnmis dist=gauss std=1/1
        vary vthpmis dist=gauss std=1/1
        vary dlpmis dist=gauss std=1/1
        vary dwpmis dist=gauss std=1/1
        vary toxpmis dist=gauss std=1/1
        }
    }

include "rf018.scs" section=mos
endsection fs

section mc

parameters par1=0
parameters par2=0
parameters par3=0
parameters par4=0
parameters par5=0
parameters vthnmis=0
parameters dlnmis=0
parameters dwnmis=0
parameters toxnmis=0
parameters vthpmis=0
parameters dlpmis=0
parameters dwpmis=0
parameters toxpmis=0
parameters a1n=par1
parameters a1p=par2
parameters a2np=par3
parameters a3np=par4
parameters a4np=par5
parameters fac_n=1.00 * 2.4
parameters fac_p=1.00 * 2.1
parameters du0n=a1n * fac_n * ( - 0.06e-2) + a4np * fac_n * ( - 0.02e-2)
parameters dlu0n=a1n * fac_n * ( - 0.22e-9)
parameters dwu0n=a1n * fac_n * ( - 0.00e-9)
parameters dpu0n=a1n * fac_n * ( - 1.0e-16)
parameters dvthn=a1n * fac_n * 0.0095
parameters dlvthn=a1n * fac_n * 1.05e-9
parameters dwvthn=a1n * fac_n * 2.25e-9
parameters dpvthn=a1n * fac_n * 1.0e-15
parameters toxn=4.08e-09 + a4np * fac_n * 0.5e-10
parameters dxln=a2np * fac_n * 0.8e-8
parameters dxwn=a3np * fac_n * 1.20e-8
parameters dk2n=a1n * fac_n * 0.002 + a4np * fac_n * 0.001
parameters dlk2n=a1n * fac_n * 0.12e-8 + a4np * fac_n * 0.10e-8
parameters dvsatn= - a1n * fac_n * 0.27e4
parameters dwvsatn= - a1n * fac_n * 0.3e-3
parameters deta0n=0.0 * a1n * fac_n
parameters dleta0n= - 0.08e-9 * 0.5 * (a1n * fac_n - sqrt(a1n * fac_n * a1n * fac_n
+ + 1e-8)) - 0.8e-10 * 0.5 * (a2np * fac_n - sqrt(a2np * fac_n * a2np * fac_n +
+ 1e-8))
parameters dweta0n=0
parameters dpeta0n= - 0.0e-16 * 0.5 * (a1n * fac_n - sqrt(a1n * fac_n * a1n * fac_n
+ + 1e-8)) - 1.0e-16 * 0.5 * (a2np * fac_n - sqrt(a2np * fac_n * a2np * fac_n +
+ 1e-8)) + 1.0e-16 * 0.5 * (a3np * fac_n + sqrt(a3np * fac_n * a3np * fac_n + 1e-8))
parameters dnfactorn=a1n * fac_n * 0
parameters dlnfactorn=a1n * fac_n * 1.5e-8 + a2np * fac_n * 1.1e-8
parameters dwnfactorn=a1n * fac_n * 0
parameters dpnfactorn=a1n * fac_n * 0.0e-15 + a2np * fac_n * 0.2e-15 - a3np * fac_n
+ * 0.2e-15
parameters dvoffn= - a1n * fac_n * 0.003
parameters dlvoffn= - a1n * fac_n * 0.000
parameters dwvoffn= - a1n * fac_n * 0.000
parameters dpvoffn= - a1n * fac_n * 0.0e-15 - a2np * fac_n * 0.43e-15 + a3np * fac_n
+ * 0.43e-15
parameters du0p=a1p * fac_p * ( - 0.001e-2) + a4np * fac_p * ( - 0.001e-2)
parameters dlu0p=a1p * fac_p * ( - 0.05e-9)
parameters dwu0p=a1p * fac_p * (0e-9)
parameters dpu0p=a1p * fac_p * ( - 0.05e-16)
parameters dvthp=a1p * fac_p * ( - 0.0125)
parameters dlvthp=a1p * fac_p * ( - 0.8e-9)
parameters dwvthp=a1p * fac_p * ( - 1.6e-9)
parameters dpvthp=a1p * fac_p * ( - 0.2e-15)
parameters toxp=4.08e-09 + a4np * fac_p * 0.5e-10
parameters dxlp=a2np * fac_p * 0.8e-8
parameters dxwp=a3np * fac_p * 1.20e-8
parameters drdswp=0
parameters dk2p=a1p * fac_p * 0.002 + a4np * fac_p * 0.0001
parameters dlk2p=a1p * fac_p * 0.08e-8 + a4np * fac_p * 0.04e-8
parameters dvsatp= - a1p * fac_p * 1.00e4
parameters dwvsatp= - a1p * fac_p * 0.3e-3
parameters deta0p=0
parameters dleta0p= - 0e-10 * 0.5 * (a1p * fac_p - sqrt(a1p * fac_p * a1p * fac_p
+ + 1e-8)) - 1.6e-10 * 0.5 * (a2np * fac_p - sqrt(a2np * fac_p * a2np * fac_p +
+ 1e-8))
parameters dweta0p=0
parameters dpeta0p= - 0.1e-16 * 0.5 * (a1p * fac_p - sqrt(a1p * fac_p * a1p * fac_p
+ + 1e-8)) - 0.5e-16 * 0.5 * (a2np * fac_p - sqrt(a2np * fac_p * a2np * fac_p +
+ 1e-8)) + 0.5e-16 * 0.5 * (a3np * fac_p + sqrt(a3np * fac_p * a3np * fac_p + 1e-8))
parameters dnfactorp=a1p * fac_p * 0
parameters dlnfactorp= - a1p * fac_p * 0.5e-8 + a2np * fac_p * 1.5e-8
parameters dwnfactorp= - a1p * fac_p * 0
parameters dpnfactorp=0
parameters dvoffp= - a1p * fac_p * 0.000
parameters dlvoffp=a1p * fac_p * 0.2e-8
parameters dwvoffp= - a1p * fac_p * 0.2e-8
parameters dpvoffp=a1p * fac_p * 0.9e-15 - a2np * fac_p * 0.1e-15 + a3np * fac_p
+ * 0.1e-15
parameters cjn=0.001000266 * (1 + 0.05 * a1n)
parameters cjswn=2.040547e-10 * (1 + 0.05 * a1n)
parameters cjswgn=3.340547e-10 * (1 + 0.05 * a1n)
parameters cgon=3.665e-10 * (1 - 0.05 * a4np)
parameters hdifn=2e-07
parameters rshn=6.8
parameters dk1n=0
parameters drdswn=0
parameters cjp=0.001121 * (1 + 0.05 * a1p)
parameters cjswp=2.481e-10 * (1 + 0.05 * a1p)
parameters cjswgp=4.221e-10 * (1 + 0.05 * a1p)
parameters cgop=3.28e-10 * (1 - 0.05 * a4np)
parameters hdifp=2e-07
parameters rshp=7.2

statistics {
    process {
        vary par1 dist=unif N=0.57735
        vary par2 dist=unif N=0.57735
        vary par3 dist=unif N=0.57735
        vary par4 dist=unif N=0.57735
        vary par5 dist=unif N=0.57735
        }
    mismatch {
        vary vthnmis dist=gauss std=1/1
        vary dlnmis dist=gauss std=1/1
        vary dwnmis dist=gauss std=1/1
        vary toxnmis dist=gauss std=1/1
        vary vthpmis dist=gauss std=1/1
        vary dlpmis dist=gauss std=1/1
        vary dwpmis dist=gauss std=1/1
        vary toxpmis dist=gauss std=1/1
        }
    }

include "rf018.scs" section=mos
endsection mc

//  *************************************************************
//                                                              *
//                 3.3V NORMAL DEVICES LIB                      *
//                                                              *
//  *************************************************************
//  ****************************    LIBRARY OF TYPICAL CASE    ******************************
section tt_3v

parameters a1n3=0
parameters a1p3=0
parameters a2np3=0
parameters a3np3=0
parameters a4np3=0
parameters vthnmis3=0
parameters dlnmis3=0
parameters dwnmis3=0
parameters toxnmis3=0
parameters vthpmis3=0
parameters dlpmis3=0
parameters dwpmis3=0
parameters toxpmis3=0
parameters fac_n3=0.3766 * 3.6
parameters fac_p3=0.3766 * 3.2
parameters du0n3=a1n3 * fac_n3 * ( - 0.125e-2)
parameters dlu0n3=a1n3 * fac_n3 * ( - 1.35e-9)
parameters dwu0n3=a1n3 * fac_n3 * ( - 0.25e-9)
parameters dpu0n3=a1n3 * fac_n3 * ( - 15e-16)
parameters dvthn3=a1n3 * fac_n3 * 0.0155
parameters dlvthn3=a1n3 * fac_n3 * 6.2e-9
parameters dwvthn3=a1n3 * fac_n3 * 6.0e-9
parameters dpvthn3=a1n3 * fac_n3 * 6.8e-15
parameters toxn3=6.8e-09 + a4np3 * fac_n3 * 2.66e-10 * 0.5
parameters dxln3=a2np3 * fac_n3 * 1.33e-8 * 0.5
parameters dxwn3=a3np3 * fac_n3 * 2.2e-8 * 0.5
parameters dk2n3=a1n3 * fac_n3 * 0.008
parameters dlk2n3=a1n3 * fac_n3 * 0.8e-8
parameters dvsatn3= - a1n3 * fac_n3 * 0.0e4
parameters dwvsatn3= - a1n3 * fac_n3 * 0.0e-3
parameters deta0n3=0.0 * a1n3 * fac_n3
parameters dleta0n3= - 0.35e-9 * 0.5 * (a1n3 * fac_n3 - sqrt(a1n3 * fac_n3 * a1n3
+ * fac_n3 + 1e-8))
parameters dweta0n3=0
parameters dpeta0n3= - 1.5e-16 * 0.5 * (a1n3 * fac_n3 - sqrt(a1n3 * fac_n3 * a1n3
+ * fac_n3 + 1e-8))
parameters dnfactorn3=a1n3 * fac_n3 * 0
parameters dlnfactorn3=a1n3 * fac_n3 * 5e-8
parameters dwnfactorn3=a1n3 * fac_n3 * 0
parameters dpnfactorn3=a1n3 * fac_n3 * 0.0e-15
parameters dvoffn3= - a1n3 * fac_n3 * 0.003
parameters dlvoffn3= - a1n3 * fac_n3 * 1.0e-9
parameters dwvoffn3= - a1n3 * fac_n3 * 0.7e-9
parameters dpvoffn3= - a1n3 * fac_n3 * 1.0e-15
parameters du0p3=a1p3 * fac_p3 * ( - 0.042e-2)
parameters dlu0p3=a1p3 * fac_p3 * ( - 0.135e-9)
parameters dwu0p3=a1p3 * fac_p3 * ( - 0.025e-9)
parameters dpu0p3=a1p3 * fac_p3 * ( - 0.12e-16)
parameters dvthp3=a1p3 * fac_p3 * ( - 0.0175)
parameters dlvthp3=a1p3 * fac_p3 * ( - 1.47e-9)
parameters dwvthp3=a1p3 * fac_p3 * ( - 1.3e-9)
parameters dpvthp3=a1p3 * fac_p3 * ( - 2.3e-15)
parameters toxp3=6.77e-09 + a4np3 * fac_p3 * 2.66e-10 * 0.5
parameters dxlp3=a2np3 * fac_p3 * 1.33e-8 * 0.5
parameters dxwp3=a3np3 * fac_p3 * 2.2e-8 * 0.5
parameters dk2p3=a1p3 * fac_p3 * 0.01
parameters dlk2p3=a1p3 * fac_p3 * 0.18e-8
parameters dvsatp3= - a1p3 * fac_p3 * 0.00e4
parameters dwvsatp3= - a1p3 * fac_p3 * 0.0e-3
parameters deta0p3=0
parameters dleta0p3= - 1e-10 * 0.5 * (a1p3 * fac_p3 - sqrt(a1p3 * fac_p3 * a1p3
+ * fac_p3 + 1e-8))
parameters dweta0p3=0
parameters dpeta0p3= - 1.2e-16 * 0.5 * (a1p3 * fac_p3 - sqrt(a1p3 * fac_p3 * a1p3
+ * fac_p3 + 1e-8))
parameters dnfactorp3=a1p3 * fac_p3 * 0
parameters dlnfactorp3= - a1p3 * fac_p3 * 0.5e-8
parameters dwnfactorp3= - a1p3 * fac_p3 * 0
parameters dpnfactorp3=0
parameters dvoffp3= - a1p3 * fac_p3 * 0.000
parameters dlvoffp3= - a1p3 * fac_p3 * 0.0e-8
parameters dwvoffp3= - a1p3 * fac_p3 * 0.0e-8
parameters dpvoffp3= - a1p3 * fac_p3 * 0.0e-15
parameters cjn3=0.0008964788
parameters cjswn3=2.50664e-10
parameters cjswgn3=3.00664e-10
parameters cgon3=3.18e-10
parameters hdifn3=2e-07
parameters rshn3=6.8
parameters cjp3=0.00103531
parameters cjswp3=2.23115e-10
parameters cjswgp3=2.345762e-10
parameters cgop3=2.77e-10
parameters hdifp3=2e-07
parameters rshp3=7.2

statistics {
    mismatch {
        vary vthnmis3 dist=gauss std=1/1
        vary dlnmis3 dist=gauss std=1/1
        vary dwnmis3 dist=gauss std=1/1
        vary toxnmis3 dist=gauss std=1/1
        vary vthpmis3 dist=gauss std=1/1
        vary dlpmis3 dist=gauss std=1/1
        vary dwpmis3 dist=gauss std=1/1
        vary toxpmis3 dist=gauss std=1/1
        }
    }

include "rf018.scs" section=mos_3v
endsection tt_3v

//  ****************************  LIBRARY OF SNSP CORNER CASE  ******************************
section ss_3v

parameters a1n3=1
parameters a1p3=1
parameters a2np3=1
parameters a3np3=-1
parameters a4np3=1
parameters vthnmis3=0
parameters dlnmis3=0
parameters dwnmis3=0
parameters toxnmis3=0
parameters vthpmis3=0
parameters dlpmis3=0
parameters dwpmis3=0
parameters toxpmis3=0
parameters fac_n3=0.3766 * 3.6
parameters fac_p3=0.3766 * 3.2
parameters du0n3=a1n3 * fac_n3 * ( - 0.125e-2)
parameters dlu0n3=a1n3 * fac_n3 * ( - 1.35e-9)
parameters dwu0n3=a1n3 * fac_n3 * ( - 0.25e-9)
parameters dpu0n3=a1n3 * fac_n3 * ( - 15e-16)
parameters dvthn3=a1n3 * fac_n3 * 0.0155
parameters dlvthn3=a1n3 * fac_n3 * 6.2e-9
parameters dwvthn3=a1n3 * fac_n3 * 6.0e-9
parameters dpvthn3=a1n3 * fac_n3 * 6.8e-15
parameters toxn3=6.8e-09 + a4np3 * fac_n3 * 2.66e-10 * 0.5
parameters dxln3=a2np3 * fac_n3 * 1.33e-8 * 0.5
parameters dxwn3=a3np3 * fac_n3 * 2.2e-8 * 0.5
parameters dk2n3=a1n3 * fac_n3 * 0.008
parameters dlk2n3=a1n3 * fac_n3 * 0.8e-8
parameters dvsatn3= - a1n3 * fac_n3 * 0.0e4
parameters dwvsatn3= - a1n3 * fac_n3 * 0.0e-3
parameters deta0n3=0.0 * a1n3 * fac_n3
parameters dleta0n3= - 0.35e-9 * 0.5 * (a1n3 * fac_n3 - sqrt(a1n3 * fac_n3 * a1n3
+ * fac_n3 + 1e-8))
parameters dweta0n3=0
parameters dpeta0n3= - 1.5e-16 * 0.5 * (a1n3 * fac_n3 - sqrt(a1n3 * fac_n3 * a1n3
+ * fac_n3 + 1e-8))
parameters dnfactorn3=a1n3 * fac_n3 * 0
parameters dlnfactorn3=a1n3 * fac_n3 * 5e-8
parameters dwnfactorn3=a1n3 * fac_n3 * 0
parameters dpnfactorn3=a1n3 * fac_n3 * 0.0e-15
parameters dvoffn3= - a1n3 * fac_n3 * 0.003
parameters dlvoffn3= - a1n3 * fac_n3 * 1.0e-9
parameters dwvoffn3= - a1n3 * fac_n3 * 0.7e-9
parameters dpvoffn3= - a1n3 * fac_n3 * 1.0e-15
parameters du0p3=a1p3 * fac_p3 * ( - 0.042e-2)
parameters dlu0p3=a1p3 * fac_p3 * ( - 0.135e-9)
parameters dwu0p3=a1p3 * fac_p3 * ( - 0.025e-9)
parameters dpu0p3=a1p3 * fac_p3 * ( - 0.12e-16)
parameters dvthp3=a1p3 * fac_p3 * ( - 0.0175)
parameters dlvthp3=a1p3 * fac_p3 * ( - 1.47e-9)
parameters dwvthp3=a1p3 * fac_p3 * ( - 1.3e-9)
parameters dpvthp3=a1p3 * fac_p3 * ( - 2.3e-15)
parameters toxp3=6.77e-09 + a4np3 * fac_p3 * 2.66e-10 * 0.5
parameters dxlp3=a2np3 * fac_p3 * 1.33e-8 * 0.5
parameters dxwp3=a3np3 * fac_p3 * 2.2e-8 * 0.5
parameters dk2p3=a1p3 * fac_p3 * 0.01
parameters dlk2p3=a1p3 * fac_p3 * 0.18e-8
parameters dvsatp3= - a1p3 * fac_p3 * 0.00e4
parameters dwvsatp3= - a1p3 * fac_p3 * 0.0e-3
parameters deta0p3=0
parameters dleta0p3= - 1e-10 * 0.5 * (a1p3 * fac_p3 - sqrt(a1p3 * fac_p3 * a1p3
+ * fac_p3 + 1e-8))
parameters dweta0p3=0
parameters dpeta0p3= - 1.2e-16 * 0.5 * (a1p3 * fac_p3 - sqrt(a1p3 * fac_p3 * a1p3
+ * fac_p3 + 1e-8))
parameters dnfactorp3=a1p3 * fac_p3 * 0
parameters dlnfactorp3= - a1p3 * fac_p3 * 0.5e-8
parameters dwnfactorp3= - a1p3 * fac_p3 * 0
parameters dpnfactorp3=0
parameters dvoffp3= - a1p3 * fac_p3 * 0.000
parameters dlvoffp3= - a1p3 * fac_p3 * 0.0e-8
parameters dwvoffp3= - a1p3 * fac_p3 * 0.0e-8
parameters dpvoffp3= - a1p3 * fac_p3 * 0.0e-15
parameters cjn3=0.0009413027
parameters cjswn3=2.631972e-10
parameters cjswgn3=3.156972e-10
parameters cgon3=3.021e-10
parameters hdifn3=2e-07
parameters rshn3=6.8
parameters cjp3=0.001087076
parameters cjswp3=2.342708e-10
parameters cjswgp3=2.46305e-10
parameters cgop3=2.6315e-10
parameters hdifp3=2e-07
parameters rshp3=7.2

statistics {
    mismatch {
        vary vthnmis3 dist=gauss std=1/1
        vary dlnmis3 dist=gauss std=1/1
        vary dwnmis3 dist=gauss std=1/1
        vary toxnmis3 dist=gauss std=1/1
        vary vthpmis3 dist=gauss std=1/1
        vary dlpmis3 dist=gauss std=1/1
        vary dwpmis3 dist=gauss std=1/1
        vary toxpmis3 dist=gauss std=1/1
        }
    }

include "rf018.scs" section=mos_3v
endsection ss_3v

//  ****************************  LIBRARY OF FNFP CORNER CASE  ******************************
section ff_3v

parameters a1n3=-1
parameters a1p3=-1
parameters a2np3=-1
parameters a3np3=1
parameters a4np3=-1
parameters vthnmis3=0
parameters dlnmis3=0
parameters dwnmis3=0
parameters toxnmis3=0
parameters vthpmis3=0
parameters dlpmis3=0
parameters dwpmis3=0
parameters toxpmis3=0
parameters fac_n3=0.3766 * 3.6
parameters fac_p3=0.3766 * 3.2
parameters du0n3=a1n3 * fac_n3 * ( - 0.125e-2)
parameters dlu0n3=a1n3 * fac_n3 * ( - 1.35e-9)
parameters dwu0n3=a1n3 * fac_n3 * ( - 0.25e-9)
parameters dpu0n3=a1n3 * fac_n3 * ( - 15e-16)
parameters dvthn3=a1n3 * fac_n3 * 0.0155
parameters dlvthn3=a1n3 * fac_n3 * 6.2e-9
parameters dwvthn3=a1n3 * fac_n3 * 6.0e-9
parameters dpvthn3=a1n3 * fac_n3 * 6.8e-15
parameters toxn3=6.8e-09 + a4np3 * fac_n3 * 2.66e-10 * 0.5
parameters dxln3=a2np3 * fac_n3 * 1.33e-8 * 0.5
parameters dxwn3=a3np3 * fac_n3 * 2.2e-8 * 0.5
parameters dk2n3=a1n3 * fac_n3 * 0.008
parameters dlk2n3=a1n3 * fac_n3 * 0.8e-8
parameters dvsatn3= - a1n3 * fac_n3 * 0.0e4
parameters dwvsatn3= - a1n3 * fac_n3 * 0.0e-3
parameters deta0n3=0.0 * a1n3 * fac_n3
parameters dleta0n3= - 0.35e-9 * 0.5 * (a1n3 * fac_n3 - sqrt(a1n3 * fac_n3 * a1n3
+ * fac_n3 + 1e-8))
parameters dweta0n3=0
parameters dpeta0n3= - 1.5e-16 * 0.5 * (a1n3 * fac_n3 - sqrt(a1n3 * fac_n3 * a1n3
+ * fac_n3 + 1e-8))
parameters dnfactorn3=a1n3 * fac_n3 * 0
parameters dlnfactorn3=a1n3 * fac_n3 * 5e-8
parameters dwnfactorn3=a1n3 * fac_n3 * 0
parameters dpnfactorn3=a1n3 * fac_n3 * 0.0e-15
parameters dvoffn3= - a1n3 * fac_n3 * 0.003
parameters dlvoffn3= - a1n3 * fac_n3 * 1.0e-9
parameters dwvoffn3= - a1n3 * fac_n3 * 0.7e-9
parameters dpvoffn3= - a1n3 * fac_n3 * 1.0e-15
parameters du0p3=a1p3 * fac_p3 * ( - 0.042e-2)
parameters dlu0p3=a1p3 * fac_p3 * ( - 0.135e-9)
parameters dwu0p3=a1p3 * fac_p3 * ( - 0.025e-9)
parameters dpu0p3=a1p3 * fac_p3 * ( - 0.12e-16)
parameters dvthp3=a1p3 * fac_p3 * ( - 0.0175)
parameters dlvthp3=a1p3 * fac_p3 * ( - 1.47e-9)
parameters dwvthp3=a1p3 * fac_p3 * ( - 1.3e-9)
parameters dpvthp3=a1p3 * fac_p3 * ( - 2.3e-15)
parameters toxp3=6.77e-09 + a4np3 * fac_p3 * 2.66e-10 * 0.5
parameters dxlp3=a2np3 * fac_p3 * 1.33e-8 * 0.5
parameters dxwp3=a3np3 * fac_p3 * 2.2e-8 * 0.5
parameters dk2p3=a1p3 * fac_p3 * 0.01
parameters dlk2p3=a1p3 * fac_p3 * 0.18e-8
parameters dvsatp3= - a1p3 * fac_p3 * 0.00e4
parameters dwvsatp3= - a1p3 * fac_p3 * 0.0e-3
parameters deta0p3=0
parameters dleta0p3= - 1e-10 * 0.5 * (a1p3 * fac_p3 - sqrt(a1p3 * fac_p3 * a1p3
+ * fac_p3 + 1e-8))
parameters dweta0p3=0
parameters dpeta0p3= - 1.2e-16 * 0.5 * (a1p3 * fac_p3 - sqrt(a1p3 * fac_p3 * a1p3
+ * fac_p3 + 1e-8))
parameters dnfactorp3=a1p3 * fac_p3 * 0
parameters dlnfactorp3= - a1p3 * fac_p3 * 0.5e-8
parameters dwnfactorp3= - a1p3 * fac_p3 * 0
parameters dpnfactorp3=0
parameters dvoffp3= - a1p3 * fac_p3 * 0.000
parameters dlvoffp3= - a1p3 * fac_p3 * 0.0e-8
parameters dwvoffp3= - a1p3 * fac_p3 * 0.0e-8
parameters dpvoffp3= - a1p3 * fac_p3 * 0.0e-15
parameters cjn3=0.0008516549
parameters cjswn3=2.381308e-10
parameters cjswgn3=2.856308e-10
parameters cgon3=3.339e-10
parameters hdifn3=2e-07
parameters rshn3=6.8
parameters cjp3=0.0009835445
parameters cjswp3=2.119593e-10
parameters cjswgp3=2.228474e-10
parameters cgop3=2.9085e-10
parameters hdifp3=2e-07
parameters rshp3=7.2

statistics {
    mismatch {
        vary vthnmis3 dist=gauss std=1/1
        vary dlnmis3 dist=gauss std=1/1
        vary dwnmis3 dist=gauss std=1/1
        vary toxnmis3 dist=gauss std=1/1
        vary vthpmis3 dist=gauss std=1/1
        vary dlpmis3 dist=gauss std=1/1
        vary dwpmis3 dist=gauss std=1/1
        vary toxpmis3 dist=gauss std=1/1
        }
    }

include "rf018.scs" section=mos_3v
endsection ff_3v

//  ****************************  LIBRARY OF SNFP CORNER CASE  ******************************
section sf_3v

parameters a1n3=1
parameters a1p3=-1
parameters a2np3=0
parameters a3np3=0
parameters a4np3=0
parameters vthnmis3=0
parameters dlnmis3=0
parameters dwnmis3=0
parameters toxnmis3=0
parameters vthpmis3=0
parameters dlpmis3=0
parameters dwpmis3=0
parameters toxpmis3=0
parameters fac_n3=0.3766 * 3.6
parameters fac_p3=0.3766 * 3.2
parameters du0n3=a1n3 * fac_n3 * ( - 0.125e-2)
parameters dlu0n3=a1n3 * fac_n3 * ( - 1.35e-9)
parameters dwu0n3=a1n3 * fac_n3 * ( - 0.25e-9)
parameters dpu0n3=a1n3 * fac_n3 * ( - 15e-16)
parameters dvthn3=a1n3 * fac_n3 * 0.0155
parameters dlvthn3=a1n3 * fac_n3 * 6.2e-9
parameters dwvthn3=a1n3 * fac_n3 * 6.0e-9
parameters dpvthn3=a1n3 * fac_n3 * 6.8e-15
parameters toxn3=6.8e-09 + a4np3 * fac_n3 * 2.66e-10 * 0.5
parameters dxln3=a2np3 * fac_n3 * 1.33e-8 * 0.5
parameters dxwn3=a3np3 * fac_n3 * 2.2e-8 * 0.5
parameters dk2n3=a1n3 * fac_n3 * 0.008
parameters dlk2n3=a1n3 * fac_n3 * 0.8e-8
parameters dvsatn3= - a1n3 * fac_n3 * 0.0e4
parameters dwvsatn3= - a1n3 * fac_n3 * 0.0e-3
parameters deta0n3=0.0 * a1n3 * fac_n3
parameters dleta0n3= - 0.35e-9 * 0.5 * (a1n3 * fac_n3 - sqrt(a1n3 * fac_n3 * a1n3
+ * fac_n3 + 1e-8))
parameters dweta0n3=0
parameters dpeta0n3= - 1.5e-16 * 0.5 * (a1n3 * fac_n3 - sqrt(a1n3 * fac_n3 * a1n3
+ * fac_n3 + 1e-8))
parameters dnfactorn3=a1n3 * fac_n3 * 0
parameters dlnfactorn3=a1n3 * fac_n3 * 5e-8
parameters dwnfactorn3=a1n3 * fac_n3 * 0
parameters dpnfactorn3=a1n3 * fac_n3 * 0.0e-15
parameters dvoffn3= - a1n3 * fac_n3 * 0.003
parameters dlvoffn3= - a1n3 * fac_n3 * 1.0e-9
parameters dwvoffn3= - a1n3 * fac_n3 * 0.7e-9
parameters dpvoffn3= - a1n3 * fac_n3 * 1.0e-15
parameters du0p3=a1p3 * fac_p3 * ( - 0.042e-2)
parameters dlu0p3=a1p3 * fac_p3 * ( - 0.135e-9)
parameters dwu0p3=a1p3 * fac_p3 * ( - 0.025e-9)
parameters dpu0p3=a1p3 * fac_p3 * ( - 0.12e-16)
parameters dvthp3=a1p3 * fac_p3 * ( - 0.0175)
parameters dlvthp3=a1p3 * fac_p3 * ( - 1.47e-9)
parameters dwvthp3=a1p3 * fac_p3 * ( - 1.3e-9)
parameters dpvthp3=a1p3 * fac_p3 * ( - 2.3e-15)
parameters toxp3=6.77e-09 + a4np3 * fac_p3 * 2.66e-10 * 0.5
parameters dxlp3=a2np3 * fac_p3 * 1.33e-8 * 0.5
parameters dxwp3=a3np3 * fac_p3 * 2.2e-8 * 0.5
parameters dk2p3=a1p3 * fac_p3 * 0.01
parameters dlk2p3=a1p3 * fac_p3 * 0.18e-8
parameters dvsatp3= - a1p3 * fac_p3 * 0.00e4
parameters dwvsatp3= - a1p3 * fac_p3 * 0.0e-3
parameters deta0p3=0
parameters dleta0p3= - 1e-10 * 0.5 * (a1p3 * fac_p3 - sqrt(a1p3 * fac_p3 * a1p3
+ * fac_p3 + 1e-8))
parameters dweta0p3=0
parameters dpeta0p3= - 1.2e-16 * 0.5 * (a1p3 * fac_p3 - sqrt(a1p3 * fac_p3 * a1p3
+ * fac_p3 + 1e-8))
parameters dnfactorp3=a1p3 * fac_p3 * 0
parameters dlnfactorp3= - a1p3 * fac_p3 * 0.5e-8
parameters dwnfactorp3= - a1p3 * fac_p3 * 0
parameters dpnfactorp3=0
parameters dvoffp3= - a1p3 * fac_p3 * 0.000
parameters dlvoffp3= - a1p3 * fac_p3 * 0.0e-8
parameters dwvoffp3= - a1p3 * fac_p3 * 0.0e-8
parameters dpvoffp3= - a1p3 * fac_p3 * 0.0e-15
parameters cjn3=0.0009413027
parameters cjswn3=2.631972e-10
parameters cjswgn3=3.156972e-10
parameters cgon3=3.18e-10
parameters hdifn3=2e-07
parameters rshn3=6.8
parameters cjp3=0.0009835445
parameters cjswp3=2.119593e-10
parameters cjswgp3=2.228474e-10
parameters cgop3=2.77e-10
parameters hdifp3=2e-07
parameters rshp3=7.2

statistics {
    mismatch {
        vary vthnmis3 dist=gauss std=1/1
        vary dlnmis3 dist=gauss std=1/1
        vary dwnmis3 dist=gauss std=1/1
        vary toxnmis3 dist=gauss std=1/1
        vary vthpmis3 dist=gauss std=1/1
        vary dlpmis3 dist=gauss std=1/1
        vary dwpmis3 dist=gauss std=1/1
        vary toxpmis3 dist=gauss std=1/1
        }
    }

include "rf018.scs" section=mos_3v
endsection sf_3v

//  ****************************  LIBRARY OF FNSP CORNER CASE  ******************************
section fs_3v

parameters a1n3=-1
parameters a1p3=1
parameters a2np3=0
parameters a3np3=0
parameters a4np3=0
parameters vthnmis3=0
parameters dlnmis3=0
parameters dwnmis3=0
parameters toxnmis3=0
parameters vthpmis3=0
parameters dlpmis3=0
parameters dwpmis3=0
parameters toxpmis3=0
parameters fac_n3=0.3766 * 3.6
parameters fac_p3=0.3766 * 3.2
parameters du0n3=a1n3 * fac_n3 * ( - 0.125e-2)
parameters dlu0n3=a1n3 * fac_n3 * ( - 1.35e-9)
parameters dwu0n3=a1n3 * fac_n3 * ( - 0.25e-9)
parameters dpu0n3=a1n3 * fac_n3 * ( - 15e-16)
parameters dvthn3=a1n3 * fac_n3 * 0.0155
parameters dlvthn3=a1n3 * fac_n3 * 6.2e-9
parameters dwvthn3=a1n3 * fac_n3 * 6.0e-9
parameters dpvthn3=a1n3 * fac_n3 * 6.8e-15
parameters toxn3=6.8e-09 + a4np3 * fac_n3 * 2.66e-10 * 0.5
parameters dxln3=a2np3 * fac_n3 * 1.33e-8 * 0.5
parameters dxwn3=a3np3 * fac_n3 * 2.2e-8 * 0.5
parameters dk2n3=a1n3 * fac_n3 * 0.008
parameters dlk2n3=a1n3 * fac_n3 * 0.8e-8
parameters dvsatn3= - a1n3 * fac_n3 * 0.0e4
parameters dwvsatn3= - a1n3 * fac_n3 * 0.0e-3
parameters deta0n3=0.0 * a1n3 * fac_n3
parameters dleta0n3= - 0.35e-9 * 0.5 * (a1n3 * fac_n3 - sqrt(a1n3 * fac_n3 * a1n3
+ * fac_n3 + 1e-8))
parameters dweta0n3=0
parameters dpeta0n3= - 1.5e-16 * 0.5 * (a1n3 * fac_n3 - sqrt(a1n3 * fac_n3 * a1n3
+ * fac_n3 + 1e-8))
parameters dnfactorn3=a1n3 * fac_n3 * 0
parameters dlnfactorn3=a1n3 * fac_n3 * 5e-8
parameters dwnfactorn3=a1n3 * fac_n3 * 0
parameters dpnfactorn3=a1n3 * fac_n3 * 0.0e-15
parameters dvoffn3= - a1n3 * fac_n3 * 0.003
parameters dlvoffn3= - a1n3 * fac_n3 * 1.0e-9
parameters dwvoffn3= - a1n3 * fac_n3 * 0.7e-9
parameters dpvoffn3= - a1n3 * fac_n3 * 1.0e-15
parameters du0p3=a1p3 * fac_p3 * ( - 0.042e-2)
parameters dlu0p3=a1p3 * fac_p3 * ( - 0.135e-9)
parameters dwu0p3=a1p3 * fac_p3 * ( - 0.025e-9)
parameters dpu0p3=a1p3 * fac_p3 * ( - 0.12e-16)
parameters dvthp3=a1p3 * fac_p3 * ( - 0.0175)
parameters dlvthp3=a1p3 * fac_p3 * ( - 1.47e-9)
parameters dwvthp3=a1p3 * fac_p3 * ( - 1.3e-9)
parameters dpvthp3=a1p3 * fac_p3 * ( - 2.3e-15)
parameters toxp3=6.77e-09 + a4np3 * fac_p3 * 2.66e-10 * 0.5
parameters dxlp3=a2np3 * fac_p3 * 1.33e-8 * 0.5
parameters dxwp3=a3np3 * fac_p3 * 2.2e-8 * 0.5
parameters dk2p3=a1p3 * fac_p3 * 0.01
parameters dlk2p3=a1p3 * fac_p3 * 0.18e-8
parameters dvsatp3= - a1p3 * fac_p3 * 0.00e4
parameters dwvsatp3= - a1p3 * fac_p3 * 0.0e-3
parameters deta0p3=0
parameters dleta0p3= - 1e-10 * 0.5 * (a1p3 * fac_p3 - sqrt(a1p3 * fac_p3 * a1p3
+ * fac_p3 + 1e-8))
parameters dweta0p3=0
parameters dpeta0p3= - 1.2e-16 * 0.5 * (a1p3 * fac_p3 - sqrt(a1p3 * fac_p3 * a1p3
+ * fac_p3 + 1e-8))
parameters dnfactorp3=a1p3 * fac_p3 * 0
parameters dlnfactorp3= - a1p3 * fac_p3 * 0.5e-8
parameters dwnfactorp3= - a1p3 * fac_p3 * 0
parameters dpnfactorp3=0
parameters dvoffp3= - a1p3 * fac_p3 * 0.000
parameters dlvoffp3= - a1p3 * fac_p3 * 0.0e-8
parameters dwvoffp3= - a1p3 * fac_p3 * 0.0e-8
parameters dpvoffp3= - a1p3 * fac_p3 * 0.0e-15
parameters cjn3=0.0008516549
parameters cjswn3=2.381308e-10
parameters cjswgn3=2.856308e-10
parameters cgon3=3.18e-10
parameters hdifn3=2e-07
parameters rshn3=6.8
parameters cjp3=0.001087076
parameters cjswp3=2.342708e-10
parameters cjswgp3=2.46305e-10
parameters cgop3=2.77e-10
parameters hdifp3=2e-07
parameters rshp3=7.2

statistics {
    mismatch {
        vary vthnmis3 dist=gauss std=1/1
        vary dlnmis3 dist=gauss std=1/1
        vary dwnmis3 dist=gauss std=1/1
        vary toxnmis3 dist=gauss std=1/1
        vary vthpmis3 dist=gauss std=1/1
        vary dlpmis3 dist=gauss std=1/1
        vary dwpmis3 dist=gauss std=1/1
        vary toxpmis3 dist=gauss std=1/1
        }
    }

include "rf018.scs" section=mos_3v
endsection fs_3v

//  ****************************    LIBRARY OF statistical model    ******************************
section mc_3v

parameters par13=0
parameters par23=0
parameters par33=0
parameters par43=0
parameters par53=0
parameters vthnmis3=0
parameters dlnmis3=0
parameters dwnmis3=0
parameters toxnmis3=0
parameters vthpmis3=0
parameters dlpmis3=0
parameters dwpmis3=0
parameters toxpmis3=0
parameters a1n3=par13
parameters a1p3=par23
parameters a2np3=par33
parameters a3np3=par43
parameters a4np3=par53
parameters fac_n3=3.6
parameters fac_p3=3.2
parameters du0n3=a1n3 * fac_n3 * ( - 0.05e-2) + a4np3 * fac_n3 * ( - 0.02e-2)
parameters dlu0n3=a1n3 * fac_n3 * ( - 0.8e-9)
parameters dwu0n3=a1n3 * fac_n3 * ( - 0.11e-9)
parameters dpu0n3=a1n3 * fac_n3 * ( - 4e-16)
parameters dvthn3=a1n3 * fac_n3 * 0.009
parameters dlvthn3=a1n3 * fac_n3 * 3.0e-9
parameters dwvthn3=a1n3 * fac_n3 * 2.3e-9
parameters dpvthn3=a1n3 * fac_n3 * 1.1e-15
parameters toxn3=6.8e-09 + a4np3 * fac_n3 * 0.5e-10
parameters dxln3=a2np3 * fac_n3 * 0.8e-8
parameters dxwn3=a3np3 * fac_n3 * 1.20e-8
parameters dk2n3=a1n3 * fac_n3 * 0.0047 + a4np3 * fac_n3 * 0.0004
parameters dlk2n3=a1n3 * fac_n3 * 0.28e-8 + a4np3 * fac_n3 * 0.15e-8
parameters dvsatn3= - a1n3 * fac_n3 * 0.030e4
parameters dwvsatn3= - a1n3 * fac_n3 * 0.9e-3
parameters deta0n3=0.0 * a1n3 * fac_n3
parameters dleta0n3= - 0.0e-10 * 0.5 * (a1n3 * fac_n3 - sqrt(a1n3 * fac_n3 * a1n3
+ * fac_n3 + 1e-8)) - 1.0e-10 * 0.5 * (a2np3 * fac_n3 - sqrt(a2np3 * fac_n3 * a2np3
+ * fac_n3 + 1e-8))
parameters dweta0n3= - 1e-9 * 0.5 * (a1n3 * fac_n3 - sqrt(a1n3 * fac_n3 * a1n3 *
+ fac_n3 + 1e-4)) * 0
parameters dpeta0n3= - 0.0e-16 * 0.5 * (a1n3 * fac_n3 - sqrt(a1n3 * fac_n3 * a1n3
+ * fac_n3 + 1e-8)) - 0.4e-16 * 0.5 * (a2np3 * fac_n3 - sqrt(a2np3 * fac_n3 * a2np3
+ * fac_n3 + 1e-8)) + 0.4e-16 * 0.5 * (a3np3 * fac_n3 + sqrt(a3np3 * fac_n3 * a3np3
+ * fac_n3 + 1e-8))
parameters dnfactorn3=0
parameters dlnfactorn3=a1n3 * fac_n3 * 1.5e-8 + a2np3 * fac_n3 * 1.1e-8
parameters dwnfactorn3=0
parameters dpnfactorn3=a1n3 * fac_n3 * 0.6e-15 + a2np3 * fac_n3 * 1.2e-15 - a3np3
+ * fac_n3 * 1.2e-15
parameters dvoffn3= - a1n3 * fac_n3 * 0.000
parameters dlvoffn3= - a1n3 * fac_n3 * 0.04e-8
parameters dwvoffn3= - a1n3 * fac_n3 * 0.05e-8
parameters dpvoffn3=a1n3 * fac_n3 * 1.0e-15 - a2np3 * fac_n3 * 0.55e-15 + a3np3
+ * fac_n3 * 0.55e-15
parameters du0p3=a1p3 * fac_p3 * ( - 0.00e-2) + a4np3 * fac_p3 * ( - 0.01e-2)
parameters dlu0p3=a1p3 * fac_p3 * ( - 0.07e-9)
parameters dwu0p3=a1p3 * fac_p3 * ( - 0.00e-9)
parameters dpu0p3=a1p3 * fac_p3 * ( - 0.1e-16)
parameters dvthp3=a1p3 * fac_p3 * ( - 0.005)
parameters dlvthp3=a1p3 * fac_p3 * ( - 0.6e-9)
parameters dwvthp3=a1p3 * fac_p3 * ( - 2.0e-9)
parameters dpvthp3=a1p3 * fac_p3 * ( - 0.6e-15)
parameters toxp3=6.77e-09 + a4np3 * fac_p3 * 1.0e-10
parameters dxlp3=a2np3 * fac_p3 * 0.8e-8
parameters dxwp3=a3np3 * fac_p3 * 1.20e-8
parameters dk2p3=a1p3 * fac_p3 * 0.003 + a4np3 * fac_p3 * 0.002
parameters dlk2p3=a1p3 * fac_p3 * 0.08e-8 + a4np3 * fac_p3 * 0.04e-8
parameters dvsatp3= - a1p3 * fac_p3 * 0.000e4
parameters dwvsatp3= - a1p3 * fac_p3 * 0.2e-3
parameters deta0p3=0
parameters dleta0p3= - 0e-10 * 0.5 * (a1p3 * fac_p3 - sqrt(a1p3 * fac_p3 * a1p3
+ * fac_p3 + 1e-8)) - 0.4e-10 * 0.5 * (a2np3 * fac_p3 - sqrt(a2np3 * fac_p3 * a2np3
+ * fac_p3 + 1e-8))
parameters dweta0p3=0
parameters dpeta0p3= - 0.2e-16 * 0.5 * (a1p3 * fac_p3 - sqrt(a1p3 * fac_p3 * a1p3
+ * fac_p3 + 1e-8)) - 0.18e-16 * 0.5 * (a2np3 * fac_p3 - sqrt(a2np3 * fac_p3 * a2np3
+ * fac_p3 + 1e-8)) + 0.18e-16 * 0.5 * (a3np3 * fac_p3 + sqrt(a3np3 * fac_p3 * a3np3
+ * fac_p3 + 1e-8))
parameters dnfactorp3=a1p3 * fac_p3 * 0
parameters dlnfactorp3= - a1p3 * fac_p3 * 1.0e-8 + a2np3 * fac_p3 * 1.5e-8
parameters dwnfactorp3= - a1p3 * fac_p3 * 0
parameters dpnfactorp3=0
parameters dvoffp3= - a1p3 * fac_p3 * 0.002
parameters dlvoffp3=a1p3 * fac_p3 * 0.15e-8
parameters dwvoffp3= - a1p3 * fac_p3 * 0.4e-8
parameters dpvoffp3=a1p3 * fac_p3 * 1.0e-15 - a2np3 * fac_p3 * 0.2e-15 + a3np3 *
+ fac_p3 * 0.2e-15
parameters cjn3=0.0008964788 * (1 + 0.05 * a1n3)
parameters cjswn3=2.50664e-10 * (1 + 0.05 * a1n3)
parameters cjswgn3=3.00664e-10 * (1 + 0.05 * a1n3)
parameters cgon3=3.18e-10 * (1 - 0.05 * a4np3)
parameters hdifn3=2e-07
parameters rshn3=6.8
parameters cjp3=0.00103531 * (1 + 0.05 * a1p3)
parameters cjswp3=2.23115e-10 * (1 + 0.05 * a1p3)
parameters cjswgp3=2.345762e-10 * (1 + 0.05 * a1p3)
parameters cgop3=2.77e-10 * (1 - 0.05 * a4np3)
parameters hdifp3=2e-07
parameters rshp3=7.2

statistics {
    process {
        vary par13 dist=gauss std=1/6
        vary par23 dist=gauss std=1/6
        vary par33 dist=gauss std=1/6
        vary par43 dist=gauss std=1/6
        vary par53 dist=gauss std=1/6
        }
    mismatch {
        vary vthnmis3 dist=gauss std=1/1
        vary dlnmis3 dist=gauss std=1/1
        vary dwnmis3 dist=gauss std=1/1
        vary toxnmis3 dist=gauss std=1/1
        vary vthpmis3 dist=gauss std=1/1
        vary dlpmis3 dist=gauss std=1/1
        vary dwpmis3 dist=gauss std=1/1
        vary toxpmis3 dist=gauss std=1/1
        }
    }

include "rf018.scs" section=mos_3v
endsection mc_3v

//  *****************************************************************************************
//  *************************************************************
//                                                              *
//                1.8V NATIVE NMOS LIB                          *
//                                                              *
//  *************************************************************
//  *************** CORNER_LIB OF TYPICAL MODEL ***************
section tt_na
parameters toxna=4.08e-09
parameters cjna=0.0001337865
parameters cjswna=1.553397e-10
parameters cjswgna=3.173876e-10
parameters cgona=5.553e-10
parameters dvthna=0
parameters hdifna=2e-07
parameters dxlna=0
parameters dxwna=0
include "rf018.scs" section=mosna
endsection tt_na
//  *************** CORNER_LIB OF SNSP MODEL ***************
section ss_na
parameters toxna=4.213e-09
parameters cjna=0.0001404758
parameters cjswna=1.631067e-10
parameters cjswgna=3.33257e-10
parameters cgona=5.27535e-10
parameters dvthna=0.08
parameters hdifna=2e-07
parameters dxlna=1.33e-08
parameters dxwna=-2.2e-08
include "rf018.scs" section=mosna
endsection ss_na
//  *************** CORNER_LIB OF FNFP MODEL ***************
section ff_na
parameters toxna=3.947e-09
parameters cjna=0.0001270972
parameters cjswna=1.475727e-10
parameters cjswgna=3.015182e-10
parameters cgona=5.83065e-10
parameters dvthna=-0.08
parameters hdifna=2e-07
parameters dxlna=-1.33e-08
parameters dxwna=2.2e-08
include "rf018.scs" section=mosna
endsection ff_na
//  *************** CORNER_LIB OF SNFP MODEL ***************
section sf_na
parameters toxna=4.08e-09
parameters cjna=0.0001404758
parameters cjswna=1.631067e-10
parameters cjswgna=3.33257e-10
parameters cgona=5.553e-10
parameters dvthna=0.08
parameters hdifna=2e-07
parameters dxlna=0
parameters dxwna=0
include "rf018.scs" section=mosna
endsection sf_na
//  *************** CORNER_LIB OF FNSP MODEL ***************
section fs_na
parameters toxna=4.08e-09
parameters cjna=0.0001270972
parameters cjswna=1.475727e-10
parameters cjswgna=3.015182e-10
parameters cgona=5.553e-10
parameters dvthna=-0.08
parameters hdifna=2e-07
parameters dxlna=0
parameters dxwna=0
include "rf018.scs" section=mosna
endsection fs_na
//  *************************************************************
//                                                              *
//                3.3V NATIVE NMOS LIB                          *
//                                                              *
//  *************************************************************
//  *************** CORNER_LIB OF TYPICAL MODEL ***************
section tt_3vna
parameters toxna3=6.8e-09
parameters cjna3=0.0001247448
parameters cjswna3=1.458794e-10
parameters cjswgna3=3.180842e-10
parameters cgona3=4.942e-10
parameters dvthna3=0
parameters hdifna3=2e-08
parameters dxlna3=0
parameters dxwna3=0
include "rf018.scs" section=mosna3
endsection tt_3vna
//  *************** CORNER_LIB OF SNSP MODEL ***************
section ss_3vna
parameters toxna3=7.5e-09
parameters cjna3=0.000130982
parameters cjswna3=1.531734e-10
parameters cjswgna3=3.339884e-10
parameters cgona3=4.6949e-10
parameters dvthna3=0.1
parameters hdifna3=2e-08
parameters dxlna3=1.33e-08
parameters dxwna3=-2.2e-08
include "rf018.scs" section=mosna3
endsection ss_3vna
//  *************** CORNER_LIB OF FNFP MODEL ***************
section ff_3vna
parameters toxna3=6.1e-09
parameters cjna3=0.0001185076
parameters cjswna3=1.385854e-10
parameters cjswgna3=3.0218e-10
parameters cgona3=5.1891e-10
parameters dvthna3=-0.1
parameters hdifna3=2e-08
parameters dxlna3=-1.33e-08
parameters dxwna3=2.2e-08
include "rf018.scs" section=mosna3
endsection ff_3vna
//  *************** CORNER_LIB OF SNFP MODEL ***************
section sf_3vna
parameters toxna3=6.8e-09
parameters cjna3=0.000130982
parameters cjswna3=1.531734e-10
parameters cjswgna3=3.339884e-10
parameters cgona3=4.942e-10
parameters dvthna3=0.1
parameters hdifna3=2e-08
parameters dxlna3=0
parameters dxwna3=0
include "rf018.scs" section=mosna3
endsection sf_3vna
//  *************** CORNER_LIB OF FNSP MODEL ***************
section fs_3vna
parameters toxna3=6.8e-09
parameters cjna3=0.0001185076
parameters cjswna3=1.385854e-10
parameters cjswgna3=3.0218e-10
parameters cgona3=4.942e-10
parameters dvthna3=-0.1
parameters hdifna3=2e-08
parameters dxlna3=0
parameters dxwna3=0
include "rf018.scs" section=mosna3
endsection fs_3vna
//
//  *************************************************************
//                                                              *
//             1.8V MEDIUM VT  DEVICES LIB                      *
//                                                              *
//  *************************************************************
//  ************** CORNER_LIB OF TYPICAL MODEL ****************************
section tt_m
parameters toxnm=4.08e-09
parameters toxpm=4.08e-09
parameters dxlm=0
parameters dxwm=0
parameters dvtnm=0
parameters dvtpm=0
parameters cjnm=9.278e-4
parameters cjpm=1.01574e-03
parameters cjswnm=2.126761e-10
parameters cjswpm=1.95706e-10
parameters cjswgnm=2.3838255e-10
parameters cjswgpm=2.01431e-10
parameters cgonm=3.8e-10
parameters cgopm=3.426e-10
parameters hdifnm=2e-07
parameters hdifpm=2e-07
include "rf018.scs" section=mosm
endsection tt_m
//  ************** CORNER_LIB OF SNSP MODEL ****************************
section ss_m
parameters toxnm=4.213e-09
parameters toxpm=4.213e-09
parameters dxlm=1.33e-08
parameters dxwm=-2.2e-08
parameters dvtnm=0.1
parameters dvtpm=-0.067
parameters cjnm=9.7419e-4
parameters cjpm=1.06653e-03
parameters cjswnm=2.2331e-10
parameters cjswpm=2.05491e-10
parameters cjswgnm=2.503017e-10
parameters cjswgpm=2.11503e-10
parameters cgonm=3.61e-10
parameters cgopm=3.2547e-10
parameters hdifnm=2e-07
parameters hdifpm=2e-07
include "rf018.scs" section=mosm
endsection ss_m
//  ************** CORNER_LIB OF FNFP MODEL ****************************
section ff_m
parameters toxnm=3.947e-09
parameters toxpm=3.947e-09
parameters dxlm=-1.33e-08
parameters dxwm=2.2e-08
parameters dvtnm=-0.1
parameters dvtpm=0.067
parameters cjnm=8.8141e-4
parameters cjpm=9.64953e-04
parameters cjswnm=2.020423e-10
parameters cjswpm=1.85921e-10
parameters cjswgnm=2.264634e-10
parameters cjswgpm=1.91359e-10
parameters cgonm=3.99e-10
parameters cgopm=3.5973e-10
parameters hdifnm=2e-07
parameters hdifpm=2e-07
include "rf018.scs" section=mosm
endsection ff_m
//  ************** CORNER_LIB OF SNFP MODEL ****************************
section sf_m
parameters toxnm=4.08e-09
parameters toxpm=4.08e-09
parameters dxlm=0
parameters dxwm=0
parameters dvtnm=0.1
parameters dvtpm=0.067
parameters cjnm=9.7419e-4
parameters cjpm=9.64953e-04
parameters cjswnm=2.2331e-10
parameters cjswpm=1.85921e-10
parameters cjswgnm=2.503017e-10
parameters cjswgpm=1.91359e-10
parameters cgonm=3.8e-10
parameters cgopm=3.426e-10
parameters hdifnm=2e-07
parameters hdifpm=2e-7
include "rf018.scs" section=mosm
endsection sf_m
//  ************** CORNER_LIB OF FNSP MODEL ****************************
section fs_m
parameters toxnm=4.08e-09
parameters toxpm=4.08e-09
parameters dxlm=0
parameters dxwm=0
parameters dvtnm=-0.1
parameters dvtpm=-0.067
parameters cjnm=8.8141e-4
parameters cjpm=1.06653e-03
parameters cjswnm=2.020423e-10
parameters cjswpm=2.05491e-10
parameters cjswgnm=2.264634e-10
parameters cjswgpm=2.11503e-10
parameters cgonm=3.8e-10
parameters cgopm=3.426e-10
parameters hdifnm=2e-07
parameters hdifpm=2e-7
include "rf018.scs" section=mosm
endsection fs_m
//  *************************************************************
//                                                              *
//             3.3V MEDIUM VT NMOS DEVICES LIB                  *
//                                                              *
//  *************************************************************
//
//  *************** CORNER_LIB OF TYPICAL MODEL ****************************
section tt_3m
parameters toxn3m=7e-09
parameters dxl3m=0
parameters dxw3m=0
parameters dvtn3m=0
parameters cjn3m=9.061374e-04
parameters cjswn3m=1.647367e-10
parameters cjswng3m=1.421706e-10
parameters cgon3m=3.136e-10
parameters hdifn3m=2e-07
include "rf018.scs" section=mos3m
endsection tt_3m
//  ************** CORNER_LIB OF  SNSP   MODEL ****************************
section ss_3m
parameters toxn3m=7.7e-09
parameters dxl3m=1.33e-8
parameters dxw3m=-2.2e-8
parameters dvtn3m=0.10
parameters cjn3m=9.514443e-04
parameters cjswn3m=1.729735e-10
parameters cjswng3m=1.492791e-10
parameters cgon3m=2.9792e-10
parameters hdifn3m=2e-07
include "rf018.scs" section=mos3m
endsection ss_3m
//  ************** CORNER_LIB OF  FNFP   MODEL ****************************
section ff_3m
parameters toxn3m=6.3e-09
parameters dxl3m=-1.33e-8
parameters dxw3m=2.2e-8
parameters dvtn3m=-0.10
parameters cjn3m=8.608305e-04
parameters cjswn3m=1.564999e-10
parameters cjswng3m=1.350621e-10
parameters cgon3m=3.2928e-10
parameters hdifn3m=2e-07
include "rf018.scs" section=mos3m
endsection ff_3m
//  ************** CORNER_LIB OF  SNFP   MODEL ****************************
section sf_3m
parameters toxn3m=7e-09
parameters dxl3m=0
parameters dxw3m=0
parameters dvtn3m=0.10
parameters cjn3m=9.514443e-04
parameters cjswn3m=1.729735e-10
parameters cjswng3m=1.492791e-10
parameters cgon3m=3.136e-10
parameters hdifn3m=2e-7
include "rf018.scs" section=mos3m
endsection sf_3m
//  ************** CORNER_LIB OF  FNSP   MODEL ****************************
section fs_3m
parameters toxn3m=7e-09
parameters dxl3m=0
parameters dxw3m=0
parameters dvtn3m=-0.10
parameters cjn3m=8.608305e-04
parameters cjswn3m=1.564999e-10
parameters cjswng3m=1.350621e-10
parameters cgon3m=3.136e-10
parameters hdifn3m=2e-7
include "rf018.scs" section=mos3m
endsection fs_3m
//
section mos
//  *************************************************************
//                                                              *
//           1.8V  NMOS BASEBAND DEVICES MODEL                  *
//                                                              *
//  *************************************************************
//  *****************************************************************************************
//
//             *
//                               1.8V CORE DEVICE MODELS
//             *
//
//             *
//  *****************************************************************************************

model nch bsim3v3  {
 1: type=n
+ lmin=1.000e-05 - dxln lmax=20.001e-006 wmin=1.0000e-05 - dxwn
+ wmax=900.001e-6 tnom=25.0 version=3.24
+ tox=toxn toxm=4.08e-09 xj=1.6000000e-07
+ nch=3.9000000e17 lln=-1 lwn=1.0000000
+ wln=1.0000000 wwn=1 lint=1.0000000e-08
+ ll=0.00 lw=0.00 lwl=0.00
+ wint=3.0000000e-09 wl=0.00 ww=0.00
+ wwl=0.00 mobmod=1 binunit=2
+ xl= - 0.02e-6 + dxln xw=0.0 + dxwn dwg=0.00
+ dwb=0.00 ldif=9.00e-08
+ hdif=hdifn rsh=rshn rd=0
+ rs=0 vth0=0.4365561 + dvthn wvth0=0 + dwvthn
+ pvth0=0 + dpvthn lvth0=0 + dlvthn k1=dk1n + 0.5142301
+ k2=1.4797844e-02 + dk2n lk2=0 + dlk2n k3=0.00
+ dvt0=0.00 dvt1=0.00 dvt2=0.00
+ dvt0w=0.00 dvt1w=0.00 dvt2w=0.00
+ nlx=0.00 w0=0.00 k3b=0.00
+ vsat=9.0000010e04 + dvsatn wvsat=0 + dwvsatn
+ ua=-6.1227400e-10 ub=2.3135539e-18 uc=1.0876087e-10
+ rdsw=drdswn + 1.7000000e02 prwb=0.00
+ prwg=0.00 wr=1.0000000 u0=du0n + 4.2203390e-02
+ a0=0.3700794 pu0=0 + dpu0n wu0=0 + dwu0n
+ lu0=0 + dlu0n keta=9.2634850e-03 a1=0.00
+ a2=0.9900000 ags=2.0000000e-02 b0=0.00
+ b1=0.00 voff= - 0.1405780 + dvoffn
+ pvoff=0 + dpvoffn wvoff=0 + dwvoffn lvoff=0 + dlvoffn
+ nfactor=1.0000000 + dnfactorn pnfactor=0 + dpnfactorn
+ wnfactor=0 + dwnfactorn lnfactor=0 + dlnfactorn cit=-1.0000001e-04
+ cdsc=0.00 cdscb=0.00 cdscd=0.00
+ eta0=5.0000000e-05 + deta0n peta0=0 + dpeta0n
+ weta0=0 + dweta0n leta0=0 + dleta0n etab=-5.0000000e-05
+ dsub=0.00 pclm=0.8000001 pdiblc1=1.0000000e-06
+ pdiblc2=6.9999990e-04 pdiblcb=1.0000000e-02 drout=0.00
+ pscbe1=2.0000003e08 pscbe2=1.0000000e-06 pvag=0.00
+ delta=1.0000000e-02 alpha0=0.0 alpha1=0.448150714
+ beta0=11.59263 kt1=-0.2240464 kt2=-3.0266136e-02
+ at=2.0000000e04 ute=-1.5799998 ua1=1.2240000e-09
+ ub1=-1.1209314e-18 uc1=1.1643822e-11 kt1l=0.00
+ prt=0 cj=cjn pb=0.6882682
+ mj=0.3595262 cjsw=cjswn pbsw=0.6882682
+ mjsw=0.2003879 cjswg=cjswgn pbswg=0.6882682
+ mjswg=0.43879 cgdo=cgon cgso=cgon
+ tcj=0.001040287 tcjsw=0.000645489 tcjswg=0.000645489
+ tpb=0.001554306 tpbsw=0.001554306 tpbswg=0.001554306
+ js=3.50e-07 jsw=1.45e-12 n=1
+ xti=3 capmod=3 nqsmod=0
+ xpart=1 cf=0 tlev=1
+ tlevc=1
+ dlc=3e-9 llc=-0.039 noimod=2
+ ef=0.874 noia=2.0e+19 noib=1.2e4
+ noic=2.5e-13 em=3.0e+07
+ minr=1e-60 imax=0.01 imelt=0.01

 2: type=n
+ lmin=1.200e-06 - dxln lmax=1.000e-05 - dxln wmin=1.0000e-05 - dxwn
+ wmax=900.001e-6 tnom=25.0 version=3.24
+ tox=toxn toxm=4.08e-09 xj=1.6000000e-07
+ nch=3.9000000e17 lln=-1 lwn=1.0000000
+ wln=1.0000000 wwn=1 lint=1.0000000e-08
+ ll=0.00 lw=0.00 lwl=0.00
+ wint=3.0000000e-09 wl=0.00 ww=0.00
+ wwl=0.00 mobmod=1 binunit=2
+ xl= - 0.02e-6 + dxln xw=0.0 + dxwn dwg=0.00
+ dwb=0.00 ldif=9.00e-08
+ hdif=hdifn rsh=rshn rd=0
+ rs=0 vth0=0.4304705 + dvthn
+ lvth0=6.0612870e-08 + dlvthn wvth0=0 + dwvthn
+ pvth0=0 + dpvthn k1=dk1n + 0.5127332 lk1=1.4908844e-08
+ k2=1.5913647e-02 + dk2n lk2= - 1.1113380e-08 + dlk2n
+ k3=0.00 dvt0=0.00 dvt1=0.00
+ dvt2=0.00 dvt0w=0.00 dvt1w=0.00
+ dvt2w=0.00 nlx=0.00 w0=0.00
+ k3b=0.00 vsat=9.0658910e04 + dvsatn
+ wvsat=0 + dwvsatn lvsat=-6.5626380e-03 ua=-5.6565540e-10
+ lua=-4.6432160e-16 ub=2.2395009e-18 lub=7.3756770e-25
+ uc=1.0484686e-10 luc=3.8983550e-17
+ rdsw=drdswn + 1.7000000e02 prwb=0.00
+ prwg=0.00 wr=1.0000000 u0=du0n + 4.1872890e-02
+ pu0=0 + dpu0n wu0=0 + dwu0n lu0=3.2918090e-09 + dlu0n
+ a0=0.4051808 la0=-3.4960930e-07 keta=1.3601619e-02
+ lketa=-4.3207810e-08 a1=0.00 a2=0.9900000
+ ags=2.0000000e-02 b0=0.00 b1=0.00
+ voff= - 0.1395267 + dvoffn pvoff=0 + dpvoffn
+ wvoff=0 + dwvoffn lvoff= - 1.0471328e-08 + dlvoffn
+ nfactor=1.0000000 + dnfactorn pnfactor=0 + dpnfactorn
+ wnfactor=0 + dwnfactorn lnfactor=0 + dlnfactorn cit=-1.2675911e-04
+ lcit=2.6652053e-10 cdsc=0.00 cdscb=0.00
+ cdscd=0.00 eta0=5.0000000e-05 + deta0n
+ peta0=0 + dpeta0n weta0=0 + dweta0n leta0=0 + dleta0n
+ etab=-5.0000000e-05 dsub=0.00 pclm=0.7736172
+ lpclm=2.6277317e-07 pdiblc1=1.0000000e-06 pdiblc2=3.9681810e-04
+ lpdiblc2=3.0196912e-09 pdiblcb=1.0000000e-02 drout=0.00
+ pscbe1=1.7363640e08 lpscbe1=2.6258185e02 pscbe2=1.0000000e-06
+ pvag=0.00 delta=1.0000000e-02 alpha0=0.0
+ alpha1=0.448150714 beta0=11.59263 kt1=-0.2240468
+ kt2=-3.0265680e-02 lkt2=-4.5534910e-12 at=2.0000000e04
+ ute=-1.5799941 lute=-5.7439530e-11 ua1=1.2240000e-09
+ ub1=-1.1209769e-18 lub1=4.5273170e-28 uc1=1.1635963e-11
+ luc1=7.8277720e-20 kt1l=0.00 prt=0
+ cj=cjn pb=0.6882682 mj=0.3595262
+ cjsw=cjswn pbsw=0.6882682 mjsw=0.2003879
+ cjswg=cjswgn pbswg=0.6882682 mjswg=0.43879
+ cgdo=cgon cgso=cgon tcj=0.001040287
+ tcjsw=0.000645489 tcjswg=0.000645489 tpb=0.001554306
+ tpbsw=0.001554306 tpbswg=0.001554306 js=3.50e-07
+ jsw=1.45e-12 n=1 xti=3
+ capmod=3 nqsmod=0 xpart=1
+ cf=0 tlev=1 tlevc=1
+ dlc=3e-9
+ llc=-0.039 noimod=2 ef=0.874
+ noia=2.0e+19 noib=1.2e4 noic=2.5e-13
+ em=3.0e+07
+ minr=1e-60 imax=0.01 imelt=0.01

 3: type=n
+ lmin=5.000e-07 - dxln lmax=1.200e-06 - dxln wmin=1.0000e-05 - dxwn
+ wmax=900.001e-6 tnom=25.0 version=3.24
+ tox=toxn toxm=4.08e-09 xj=1.6000000e-07
+ nch=3.9000000e17 lln=-1 lwn=1.0000000
+ wln=1.0000000 wwn=1 lint=1.0000000e-08
+ ll=0.00 lw=0.00 lwl=0.00
+ wint=3.0000000e-09 wl=0.00 ww=0.00
+ wwl=0.00 mobmod=1 binunit=2
+ xl= - 0.02e-6 + dxln xw=0.0 + dxwn dwg=0.00
+ dwb=0.00 ldif=9.00e-08
+ hdif=hdifn rsh=rshn rd=0
+ rs=0 vth0=0.4793240 + dvthn
+ lvth0=3.9427570e-09 + dlvthn wvth0=0 + dwvthn
+ pvth0=0 + dpvthn k1=dk1n + 0.5318048 lk1=-7.2142460e-09
+ k2=4.8649130e-03 + dk2n lk2=1.7031510e-09 + dlk2n
+ k3=0.00 dvt0=0.00 dvt1=0.00
+ dvt2=0.00 dvt0w=0.00 dvt1w=0.00
+ dvt2w=0.00 nlx=0.00 w0=0.00
+ k3b=0.00 vsat=8.5658600e04 + dvsatn
+ wvsat=0 + dwvsatn lvsat=-7.6228570e-04 ua=-1.0347512e-09
+ lua=7.9829660e-17 ub=3.0100842e-18 lub=-1.5630905e-25
+ uc=1.4678947e-10 luc=-9.6698950e-18
+ rdsw=drdswn + 1.7000000e02 prwb=0.00
+ prwg=0.00 wr=1.0000000 u0=du0n + 4.3813580e-02
+ pu0=0 + dpu0n wu0=0 + dwu0n lu0=1.0406079e-09 + dlu0n
+ a0=-0.2911571 la0=4.5814260e-07 keta=-1.5927497e-02
+ lketa=-8.9540290e-09 a1=0.00 a2=0.9900000
+ ags=4.6247400e-02 lags=-3.0446980e-08 b0=0.00
+ b1=0.00 voff= - 0.1621186 + dvoffn
+ pvoff=0 + dpvoffn wvoff=0 + dwvoffn
+ lvoff=1.5735258e-08 + dlvoffn
+ nfactor=1.0000000 + dnfactorn pnfactor=0 + dpnfactorn
+ wnfactor=0 + dwnfactorn lnfactor=0 + dlnfactorn cit=-1.5788565e-04
+ lcit=3.0262734e-10 cdsc=0.00 cdscb=0.00
+ cdscd=0.00 eta0=1.7142866e-05 + deta0n
+ peta0=0 + dpeta0n weta0=0 + dweta0n
+ leta0=3.8114280e-11 + dleta0n etab=-1.7142866e-05
+ letab=-3.8114280e-11 dsub=0.00 pclm=0.8687172
+ lpclm=1.5245718e-07 pdiblc1=1.0000000e-06 pdiblc2=1.6847569e-03
+ lpdiblc2=1.5256820e-09 pdiblcb=1.0000000e-02 drout=0.00
+ pscbe1=4.0000010e08 pscbe2=1.0000000e-06 pvag=0.00
+ delta=1.0000000e-02 alpha0=0.0 alpha1=0.448150714
+ beta0=11.59263 kt1=-0.2290285 lkt1=5.7826780e-09
+ kt2=-3.1611919e-02 lkt2=1.5570838e-09 at=2.0000000e04
+ ute=-1.3504703 lute=-2.6630502e-07 ua1=1.2266247e-09
+ lua1=-3.0446746e-18 ub1=-8.5743860e-20 lub1=-1.2004175e-24
+ uc1=6.7886830e-11 luc1=-6.5172730e-17 kt1l=0.00
+ prt=0 cj=cjn pb=0.6882682
+ mj=0.3595262 cjsw=cjswn pbsw=0.6882682
+ mjsw=0.2003879 cjswg=cjswgn pbswg=0.6882682
+ mjswg=0.43879 cgdo=cgon cgso=cgon
+ tcj=0.001040287 tcjsw=0.000645489 tcjswg=0.000645489
+ tpb=0.001554306 tpbsw=0.001554306 tpbswg=0.001554306
+ js=3.50e-07 jsw=1.45e-12 n=1
+ xti=3 capmod=3 nqsmod=0
+ xpart=1 cf=0 tlev=1
+ tlevc=1
+ dlc=3e-9 llc=-0.039 noimod=2
+ ef=0.874 noia=2.0e+19 noib=1.2e4
+ noic=2.5e-13 em=3.0e+07
+ minr=1e-60 imax=0.01 imelt=0.01

 4: type=n
+ lmin=1.8e-007 lmax=5.000e-07 - dxln wmin=1.0000e-05 - dxwn
+ wmax=900.001e-6 tnom=25.0 version=3.24
+ tox=toxn toxm=4.08e-09 xj=1.6000000e-07
+ nch=3.9000000e17 lln=-1 lwn=1.0000000
+ wln=1.0000000 wwn=1 lint=1.0000000e-08
+ ll=0.00 lw=0.00 lwl=0.00
+ wint=3.0000000e-09 wl=0.00 ww=0.00
+ wwl=0.00 mobmod=1 binunit=2
+ xl= - 0.02e-6 + dxln xw=0.0 + dxwn dwg=0.00
+ dwb=0.00 ldif=9.00e-08
+ hdif=hdifn rsh=rshn rd=0
+ rs=0 vth0=0.4752311 + dvthn
+ lvth0=5.8255010e-09 + dlvthn wvth0=0 + dwvthn
+ pvth0=0 + dpvthn k1=dk1n + 0.4096095 lk1=4.8995580e-08
+ k2=5.9309460e-02 + dk2n lk2= - 2.3341336e-08 + dlk2n
+ k3=0.00 dvt0=0.00 dvt1=0.00
+ dvt2=0.00 dvt0w=0.00 dvt1w=0.00
+ dvt2w=0.00 nlx=0.00 w0=0.00
+ k3b=0.00 vsat=8.4438960e04 + dvsatn
+ wvsat=0 + dwvsatn lvsat=-2.0125005e-04 ua=-8.5891920e-10
+ lua=-1.0530929e-18 ub=2.6581962e-18 lub=5.5594780e-27
+ uc=1.1678118e-10 luc=4.1339190e-18
+ rdsw=drdswn + 1.7000000e02 prwb=0.00
+ prwg=0.00 wr=1.0000000 u0=du0n + 4.3354470e-02
+ pu0=0 + dpu0n wu0=0 + dwu0n lu0=1.2517989e-09 + dlu0n
+ a0=0.5407774 la0=7.5452710e-08 keta=-4.1823270e-02
+ lketa=2.9580252e-09 a1=0.00 a2=0.9900000
+ ags=-1.9916179e-02 lags=-1.1735286e-11 b0=0.00
+ b1=0.00 voff= - 0.1245498 + dvoffn
+ pvoff=0 + dpvoffn wvoff=0 + dwvoffn
+ lvoff= - 1.5463618e-09 + dlvoffn
+ nfactor=1.0000000 + dnfactorn pnfactor=0 + dpnfactorn
+ wnfactor=0 + dwnfactorn lnfactor=0 + dlnfactorn cit=2.7188900e-04
+ lcit=1.0493098e-10 cdsc=0.00 cdscb=0.00
+ cdscd=0.00 eta0= - 2.9375020e-04 + deta0n
+ peta0=0 + dpeta0n weta0=0 + dweta0n
+ leta0=1.8112506e-10 + dleta0n etab=1.3875004e-03
+ letab=-6.8425020e-10 dsub=0.00 pclm=1.1076791
+ lpclm=4.2534670e-08 pdiblc1=1.0000000e-06 pdiblc2=-5.9354100e-03
+ lpdiblc2=5.0309570e-09 pdiblcb=1.0000000e-02 drout=0.00
+ pscbe1=4.0000000e08 pscbe2=1.0000000e-06 pvag=0.00
+ delta=1.0000000e-02 alpha0=0.0 alpha1=0.448150714
+ beta0=11.59263 kt1=-0.2271500 lkt1=4.9185610e-09
+ kt2=-2.9537767e-02 lkt2=6.0297430e-10 at=2.0000000e04
+ ute=-2.0822308 lute=7.0304760e-08 ua1=1.2182583e-09
+ lua1=8.0390990e-19 ub1=-3.5266740e-18 lub1=3.8241010e-25
+ uc1=-1.3815420e-10 luc1=2.9606131e-17 kt1l=0.00
+ prt=0 cj=cjn pb=0.6882682
+ mj=0.3595262 cjsw=cjswn pbsw=0.6882682
+ mjsw=0.2003879 cjswg=cjswgn pbswg=0.6882682
+ mjswg=0.43879 cgdo=cgon cgso=cgon
+ tcj=0.001040287 tcjsw=0.000645489 tcjswg=0.000645489
+ tpb=0.001554306 tpbsw=0.001554306 tpbswg=0.001554306
+ js=3.50e-07 jsw=1.45e-12 n=1
+ xti=3 capmod=3 nqsmod=0
+ xpart=1 cf=0 tlev=1
+ tlevc=1
+ dlc=3e-9 llc=-0.039 noimod=2
+ ef=0.874 noia=2.0e+19 noib=1.2e4
+ noic=2.5e-13 em=3.0e+07
+ minr=1e-60 imax=0.01 imelt=0.01

 5: type=n
+ lmin=1.000e-05 - dxln lmax=20.001e-006 wmin=1.2000e-06 - dxwn
+ wmax=1.0000e-05 - dxwn tnom=25.0 version=3.24
+ tox=toxn toxm=4.08e-09 xj=1.6000000e-07
+ nch=3.9000000e17 lln=-1 lwn=1.0000000
+ wln=1.0000000 wwn=1 lint=1.0000000e-08
+ ll=0.00 lw=0.00 lwl=0.00
+ wint=3.0000000e-09 wl=0.00 ww=0.00
+ wwl=0.00 mobmod=1 binunit=2
+ xl= - 0.02e-6 + dxln xw=0.0 + dxwn dwg=0.00
+ dwb=0.00 ldif=9.00e-08
+ hdif=hdifn rsh=rshn rd=0
+ rs=0 vth0=0.4364873 + dvthn
+ wvth0=6.8761140e-10 + dwvthn pvth0=0 + dpvthn
+ lvth0=0 + dlvthn k1=dk1n + 0.5102321 wk1=3.9956060e-08
+ k2=1.6091494e-02 + dk2n lk2=0 + dlk2n wk2=-1.2928737e-08
+ k3=0.00 dvt0=0.00 dvt1=0.00
+ dvt2=0.00 dvt0w=0.00 dvt1w=0.00
+ dvt2w=0.00 nlx=0.00 w0=0.00
+ k3b=0.00 vsat=9.0000010e04 + dvsatn
+ wvsat=0 + dwvsatn ua=-5.8859420e-10 wua=-2.3665659e-16
+ ub=2.3329335e-18 wub=-1.9367960e-25 uc=1.1057788e-10
+ wuc=-1.8159270e-17 rdsw=drdswn + 1.7000000e02
+ prwb=0.00 prwg=0.00 wr=1.0000000
+ u0=du0n + 4.3035900e-02 pu0=0 + dpu0n
+ wu0= - 8.3200990e-09 + dwu0n lu0=0 + dlu0n
+ a0=0.3702259 wa0=-1.4643313e-09 keta=1.0357677e-02
+ wketa=-1.0935369e-08 a1=0.00 a2=0.9900000
+ ags=2.0000000e-02 b0=0.00 b1=0.00
+ voff= - 0.1406671 + dvoffn pvoff=0 + dpvoffn
+ lvoff=0 + dlvoffn wvoff=8.9072240e-10 + dwvoffn
+ nfactor=1.0000000 + dnfactorn pnfactor=0 + dpnfactorn
+ wnfactor=0 + dwnfactorn lnfactor=0 + dlnfactorn cit=-1.0000001e-04
+ cdsc=0.00 cdscb=0.00 cdscd=0.00
+ eta0=5.0000000e-05 + deta0n peta0=0 + dpeta0n
+ weta0=0 + dweta0n leta0=0 + dleta0n etab=-5.0000000e-05
+ dsub=0.00 pclm=0.8000001 pdiblc1=1.0000000e-06
+ pdiblc2=6.9999990e-04 pdiblcb=1.0000000e-02 drout=0.00
+ pscbe1=2.0000003e08 pscbe2=1.0000000e-06 pvag=0.00
+ delta=1.0000000e-02 alpha0=0.0 alpha1=0.448150714
+ beta0=11.59263 kt1=-0.2232244 wkt1=-8.2151660e-09
+ kt2=-3.0428693e-02 wkt2=1.6245854e-09 at=2.0000000e04
+ ute=-1.5803809 wute=3.8084330e-09 ua1=1.2240000e-09
+ ub1=-1.0684574e-18 wub1=-5.2442470e-25 uc1=2.4230474e-11
+ wuc1=-1.2579110e-16 puc1=-1.4905616e-28 kt1l=0.00
+ prt=0 cj=cjn pb=0.6882682
+ mj=0.3595262 cjsw=cjswn pbsw=0.6882682
+ mjsw=0.2003879 cjswg=cjswgn pbswg=0.6882682
+ mjswg=0.43879 cgdo=cgon cgso=cgon
+ tcj=0.001040287 tcjsw=0.000645489 tcjswg=0.000645489
+ tpb=0.001554306 tpbsw=0.001554306 tpbswg=0.001554306
+ js=3.50e-07 jsw=1.45e-12 n=1
+ xti=3 capmod=3 nqsmod=0
+ xpart=1 cf=0 tlev=1
+ tlevc=1
+ dlc=3e-9 llc=-0.039 noimod=2
+ ef=0.874 noia=2.0e+19 noib=1.2e4
+ noic=2.5e-13 em=3.0e+07
+ minr=1e-60 imax=0.01 imelt=0.01

 6: type=n
+ lmin=1.200e-06 - dxln lmax=1.000e-05 - dxln wmin=1.2000e-06 - dxwn
+ wmax=1.0000e-05 - dxwn tnom=25.0 version=3.24
+ tox=toxn toxm=4.08e-09 xj=1.6000000e-07
+ nch=3.9000000e17 lln=-1 lwn=1.0000000
+ wln=1.0000000 wwn=1 lint=1.0000000e-08
+ ll=0.00 lw=0.00 lwl=0.00
+ wint=3.0000000e-09 wl=0.00 ww=0.00
+ wwl=0.00 mobmod=1 binunit=2
+ xl= - 0.02e-6 + dxln xw=0.0 + dxwn dwg=0.00
+ dwb=0.00 ldif=9.00e-08
+ hdif=hdifn rsh=rshn rd=0
+ rs=0 vth0=0.4303924 + dvthn
+ lvth0=6.0706090e-08 + dlvthn
+ wvth0=7.8115020e-10 + dwvthn
+ pvth0= - 9.3168750e-16 + dpvthn k1=dk1n + 0.5085090
+ lk1=1.7161611e-08 wk1=4.2216520e-08 pk1=-2.2514154e-14
+ k2=1.7310230e-02 + dk2n lk2= - 1.2138612e-08 + dlk2n
+ wk2=-1.3957471e-08 pk2=1.0246181e-14 k3=0.00
+ dvt0=0.00 dvt1=0.00 dvt2=0.00
+ dvt0w=0.00 dvt1w=0.00 dvt2w=0.00
+ nlx=0.00 w0=0.00 k3b=0.00
+ vsat=9.0678020e04 + dvsatn lvsat=-6.7530250e-03
+ wvsat= - 1.9104627e-04 + dwvsatn pvsat=1.9027204e-09
+ ua=-5.3771250e-10 lua=-5.0678040e-16 wua=-2.7926046e-16
+ pua=4.2433420e-22 ub=2.2537915e-18 lub=7.8825360e-25
+ wub=-1.4282058e-25 pub=-5.0655580e-31 uc=1.0657759e-10
+ luc=3.9842870e-17 wuc=-1.7297008e-17 puc=-8.5881340e-24
+ rdsw=drdswn + 1.7000000e02 prwb=0.00
+ prwg=0.00 wr=1.0000000 u0=du0n + 4.2730270e-02
+ lu0=3.0440912e-09 + dlu0n
+ wu0= - 8.5686630e-09 + dwu0n pu0=2.4756895e-15 + dpu0n
+ a0=0.4062600 la0=-3.5889950e-07 wa0=-1.0786144e-08
+ pa0=9.2845460e-14 keta=1.4894814e-02 lketa=-4.5189890e-08
+ wketa=-1.2924230e-08 pketa=1.9809019e-14 a1=0.00
+ a2=0.9900000 ags=2.0000000e-02 b0=0.00
+ b1=0.00 voff= - 0.1395822 + dvoffn
+ lvoff= - 1.0806052e-08 + dlvoffn
+ wvoff=5.5485390e-10 + dwvoffn
+ pvoff=3.3452410e-15 + dpvoffn
+ nfactor=1.0000000 + dnfactorn pnfactor=0 + dpnfactorn
+ wnfactor=0 + dwnfactorn lnfactor=0 + dlnfactorn cit=-1.2675911e-04
+ lcit=2.6652053e-10 cdsc=0.00 cdscb=0.00
+ cdscd=0.00 eta0=5.0000000e-05 + deta0n
+ peta0=0 + dpeta0n weta0=0 + dweta0n leta0=0 + dleta0n
+ etab=-5.0000000e-05 dsub=0.00 pclm=0.7755287
+ lpclm=2.4373449e-07 wpclm=-1.9103656e-08 ppclm=1.9027247e-13
+ pdiblc1=1.0000000e-06 pdiblc2=3.9681810e-04 lpdiblc2=3.0196912e-09
+ pdiblcb=1.0000000e-02 drout=0.00 pscbe1=1.7363640e08
+ lpscbe1=2.6258185e02 pscbe2=1.0000000e-06 pvag=0.00
+ delta=1.0000000e-02 alpha0=0.0 alpha1=0.448150714
+ beta0=11.59263 kt1=-0.2231775 lkt1=-4.6746150e-10
+ wkt1=-8.6881510e-09 pkt1=4.7109120e-15 kt2=-3.0469729e-02
+ lkt2=4.0873210e-10 wkt2=2.0392819e-09 pkt2=-4.1303770e-15
+ at=2.0000000e04 ute=-1.5809486 lute=5.6541540e-09
+ wute=9.5395260e-09 pute=-5.7081670e-14 ua1=1.2240000e-09
+ ub1=-1.0643074e-18 lub1=-4.1333620e-26 wub1=-5.6635370e-25
+ pub1=4.1761280e-31 uc1=2.4967807e-11 luc1=-7.3437550e-18
+ wuc1=-1.3323848e-16 puc1=7.4175780e-23 kt1l=0.00
+ prt=0 cj=cjn pb=0.6882682
+ mj=0.3595262 cjsw=cjswn pbsw=0.6882682
+ mjsw=0.2003879 cjswg=cjswgn pbswg=0.6882682
+ mjswg=0.43879 cgdo=cgon cgso=cgon
+ tcj=0.001040287 tcjsw=0.000645489 tcjswg=0.000645489
+ tpb=0.001554306 tpbsw=0.001554306 tpbswg=0.001554306
+ js=3.50e-07 jsw=1.45e-12 n=1
+ xti=3 capmod=3 nqsmod=0
+ xpart=1 cf=0 tlev=1
+ tlevc=1
+ dlc=3e-9 llc=-0.039 noimod=2
+ ef=0.874 noia=2.0e+19 noib=1.2e4
+ noic=2.5e-13 em=3.0e+07
+ minr=1e-60 imax=0.01 imelt=0.01

 7: type=n
+ lmin=5.000e-07 - dxln lmax=1.200e-06 - dxln wmin=1.2000e-06 - dxwn
+ wmax=1.0000e-05 - dxwn tnom=25.0 version=3.24
+ tox=toxn toxm=4.08e-09 xj=1.6000000e-07
+ nch=3.9000000e17 lln=-1 lwn=1.0000000
+ wln=1.0000000 wwn=1 lint=1.0000000e-08
+ ll=0.00 lw=0.00 lwl=0.00
+ wint=3.0000000e-09 wl=0.00 ww=0.00
+ wwl=0.00 mobmod=1 binunit=2
+ xl= - 0.02e-6 + dxln xw=0.0 + dxwn dwg=0.00
+ dwb=0.00 ldif=9.00e-08
+ hdif=hdifn rsh=rshn rd=0
+ rs=0 vth0=0.4799949 + dvthn
+ lvth0=3.1671320e-09 + dlvthn
+ wvth0= - 6.7044360e-09 + dwvthn
+ pvth0=7.7515980e-15 + dpvthn k1=dk1n + 0.5329412
+ lk1=-1.1179709e-08 wk1=-1.1356744e-08 pk1=3.9630840e-14
+ k2=3.8880950e-03 + dk2n lk2=3.4310650e-09 + dlk2n
+ wk2=9.7623110e-09 pk2=-1.7268767e-14 k3=0.00
+ dvt0=0.00 dvt1=0.00 dvt2=0.00
+ dvt0w=0.00 dvt1w=0.00 dvt2w=0.00
+ nlx=0.00 w0=0.00 k3b=0.00
+ vsat=8.5513590e04 + dvsatn lvsat=-7.6228650e-04
+ wvsat=1.4492224e-03 + dwvsatn ua=-1.0276002e-09
+ lua=6.1489260e-17 wua=-7.1467150e-17 pua=1.8329395e-22
+ ub=3.0435232e-18 lub=-1.2783527e-25 wub=-3.3419020e-25
+ pub=-2.8456703e-31 uc=1.4653272e-10 luc=-6.5050680e-18
+ wuc=2.5660584e-18 puc=-3.1629300e-23
+ rdsw=drdswn + 1.7000000e02 prwb=0.00
+ prwg=0.00 wr=1.0000000 u0=du0n + 4.4526490e-02
+ lu0=9.6047130e-10 + dlu0n
+ wu0= - 7.1248670e-09 + dwu0n pu0=8.0088650e-16 + dpu0n
+ a0=-0.3035701 la0=4.6450350e-07 wa0=1.2405528e-07
+ pa0=-6.3570630e-14 keta=-1.5493870e-02 lketa=-9.9390180e-09
+ wketa=-4.3336820e-09 pketa=9.8439870e-15 a1=0.00
+ a2=0.9900000 ags=4.9808680e-02 lags=-3.4578080e-08
+ wags=-3.5591570e-08 pags=4.1286230e-14 b0=0.00
+ b1=0.00 voff= - 0.1627226 + dvoffn
+ lvoff=1.6036822e-08 + dlvoffn
+ wvoff=6.0367980e-09 + dwvoffn
+ pvoff= - 3.0138140e-15 + dpvoffn
+ nfactor=1.0000000 + dnfactorn pnfactor=0 + dpnfactorn
+ wnfactor=0 + dwnfactorn lnfactor=0 + dlnfactorn cit=-1.5788565e-04
+ lcit=3.0262734e-10 cdsc=0.00 cdscb=0.00
+ cdscd=0.00 eta0=1.7142869e-05 + deta0n
+ peta0=0 + dpeta0n weta0=0 + dweta0n
+ leta0=3.8114280e-11 + dleta0n etab=-1.7142869e-05
+ letab=-3.8114280e-11 dsub=0.00 pclm=0.8548421
+ lpclm=1.5173094e-07 wpclm=1.3866737e-07 ppclm=7.2580320e-15
+ pdiblc1=1.0000000e-06 pdiblc2=1.7737894e-03 lpdiblc2=1.4224044e-09
+ wpdiblc2=-8.8978950e-10 ppdiblc2=1.0321563e-15 pdiblcb=1.0000000e-02
+ drout=0.00 pscbe1=4.0000010e08 pscbe2=1.0000000e-06
+ pvag=0.00 delta=1.0000000e-02 alpha0=0.0
+ alpha1=0.448150714 beta0=11.59263 kt1=-0.2286601
+ lkt1=5.8923870e-09 wkt1=-3.6818220e-09 pkt1=-1.0964308e-15
+ kt2=-3.1479932e-02 lkt2=1.5805686e-09 wkt2=-1.3190541e-09
+ pkt2=-2.3470743e-16 at=2.0000000e04 ute=-1.3089141
+ lute=-3.0990586e-07 wute=-4.1531240e-07 pute=4.3574660e-13
+ ua1=1.2269809e-09 lua1=-3.4577810e-18 wua1=-3.5591300e-18
+ pua1=4.1285910e-24 ub1=7.5674550e-20 lub1=-1.3637128e-24
+ wub1=-1.6132161e-24 pub1=1.6319734e-30 uc1=8.5944920e-11
+ luc1=-7.8077210e-17 wuc1=-1.8047248e-16 puc1=1.2896722e-22
+ kt1l=0.00 prt=0 cj=cjn
+ pb=0.6882682 mj=0.3595262 cjsw=cjswn
+ pbsw=0.6882682 mjsw=0.2003879 cjswg=cjswgn
+ pbswg=0.6882682 mjswg=0.43879 cgdo=cgon
+ cgso=cgon tcj=0.001040287 tcjsw=0.000645489
+ tcjswg=0.000645489 tpb=0.001554306 tpbsw=0.001554306
+ tpbswg=0.001554306 js=3.50e-07 jsw=1.45e-12
+ n=1 xti=3 capmod=3
+ nqsmod=0 xpart=1 cf=0
+ tlev=1 tlevc=1
+ dlc=3e-9 llc=-0.039
+ noimod=2 ef=0.874 noia=2.0e+19
+ noib=1.2e4 noic=2.5e-13 em=3.0e+07
+ minr=1e-60 imax=0.01 imelt=0.01

 8: type=n
+ lmin=1.8e-007 lmax=5.000e-07 - dxln wmin=1.2000e-06 - dxwn
+ wmax=1.0000e-05 - dxwn tnom=25.0 version=3.24
+ tox=toxn toxm=4.08e-09 xj=1.6000000e-07
+ nch=3.9000000e17 lln=-1 lwn=1.0000000
+ wln=1.0000000 wwn=1 lint=1.0000000e-08
+ ll=0.00 lw=0.00 lwl=0.00
+ wint=3.0000000e-09 wl=0.00 ww=0.00
+ wwl=0.00 mobmod=1 binunit=2
+ xl= - 0.02e-6 + dxln xw=0.0 + dxwn dwg=0.00
+ dwb=0.00 ldif=9.00e-08
+ hdif=hdifn rsh=rshn rd=0
+ rs=0 vth0=0.4751966 + dvthn
+ lvth0=5.3743360e-09 + dlvthn
+ wvth0=3.4482360e-10 + dwvthn
+ pvth0=4.5089380e-15 + dpvthn k1=dk1n + 0.4007356
+ lk1=4.9634880e-08 wk1=8.8686750e-08 pk1=-6.3891820e-15
+ k2=6.3188600e-02 + dk2n lk2= - 2.3847164e-08 + dlk2n
+ wk2=-3.8768180e-08 pk2=5.0552590e-15 k3=0.00
+ dvt0=0.00 dvt1=0.00 dvt2=0.00
+ dvt0w=0.00 dvt1w=0.00 dvt2w=0.00
+ nlx=0.00 w0=0.00 k3b=0.00
+ vsat=8.4294280e04 + dvsatn lvsat=-2.0140363e-04
+ wvsat=1.4459029e-03 + dwvsatn pvsat=1.5350395e-12
+ ua=-9.0172960e-10 lua=3.5887640e-18 wua=4.2784730e-16
+ pua=-4.6390690e-23 ub=2.7527719e-18 lub=5.9103390e-27
+ wub=-9.4519130e-25 pub=-3.5064990e-33 uc=1.2291169e-10
+ luc=4.3605990e-18 wuc=-6.1268420e-17 puc=-2.2654354e-24
+ rdsw=drdswn + 1.7000000e02 prwb=0.00
+ prwg=0.00 wr=1.0000000 u0=du0n + 4.3840840e-02
+ lu0=1.2758692e-09 + dlu0n
+ wu0= - 4.8608560e-09 + dwu0n
+ pu0= - 2.4055863e-16 + dpu0n a0=0.5262308
+ la0=8.2795080e-08 wa0=1.4537927e-07 pa0=-7.3379640e-14
+ keta=-4.4118840e-02 lketa=3.2284670e-09 wketa=2.2941933e-08
+ pketa=-2.7027957e-15 a1=0.00 a2=0.9900000
+ ags=-2.7693154e-02 lags=1.0727657e-09 wags=7.7723050e-08
+ pags=-1.0838496e-14 b0=0.00 b1=0.00
+ voff= - 0.1247105 + dvoffn
+ lvoff= - 1.4487617e-09 + dlvoffn
+ wvoff=1.6054964e-09 + dwvoffn
+ pvoff= - 9.7541500e-16 + dpvoffn
+ nfactor=1.0000000 + dnfactorn pnfactor=0 + dpnfactorn
+ wnfactor=0 + dwnfactorn lnfactor=0 + dlnfactorn cit=2.7498236e-04
+ lcit=1.0350804e-10 wcit=-3.0914837e-11 pcit=1.4220811e-17
+ cdsc=0.00 cdscb=0.00 cdscd=0.00
+ eta0= - 2.9405078e-04 + deta0n
+ leta0=1.8126334e-10 + dleta0n
+ weta0=3.0046217e-12 + dweta0n
+ peta0= - 1.3821218e-18 + dpeta0n etab=1.3878694e-03
+ letab=-6.8441990e-10 wetab=-3.6866540e-12 petab=1.6959704e-18
+ dsub=0.00 pclm=1.1010191 lpclm=3.8489530e-08
+ wpclm=6.6560680e-08 ppclm=4.0427110e-14 pdiblc1=1.0000000e-06
+ pdiblc2=-6.1190130e-03 lpdiblc2=5.0530930e-09 wpdiblc2=1.8349379e-09
+ ppdiblc2=-2.2121929e-16 pdiblcb=1.0000000e-02 drout=0.00
+ pscbe1=4.0000000e08 pscbe2=1.0000000e-06 pvag=0.00
+ delta=1.0000000e-02 alpha0=0.0 alpha1=0.448150714
+ beta0=11.59263 kt1=-0.2269240 lkt1=5.0937890e-09
+ wkt1=-2.2583577e-09 pkt1=-1.7512235e-15 kt2=-2.9338669e-02
+ lkt2=5.9558730e-10 wkt2=-1.9897783e-09 pkt2=7.3825670e-17
+ at=2.0000000e04 ute=-2.1610963 lute=8.2097990e-08
+ wute=7.8818350e-07 pute=-1.1786150e-13 ua1=1.2174792e-09
+ lua1=9.1298580e-19 wua1=7.7858620e-18 pua1=-1.0901051e-24
+ ub1=-3.8124500e-18 lub1=4.2482470e-25 wub1=2.8560549e-24
+ pub1=-4.2389140e-31 uc1=-1.5406690e-10 luc1=3.2328220e-17
+ wuc1=1.5903152e-16 puc1=-2.7204607e-23 kt1l=0.00
+ prt=0 cj=cjn pb=0.6882682
+ mj=0.3595262 cjsw=cjswn pbsw=0.6882682
+ mjsw=0.2003879 cjswg=cjswgn pbswg=0.6882682
+ mjswg=0.43879 cgdo=cgon cgso=cgon
+ tcj=0.001040287 tcjsw=0.000645489 tcjswg=0.000645489
+ tpb=0.001554306 tpbsw=0.001554306 tpbswg=0.001554306
+ js=3.50e-07 jsw=1.45e-12 n=1
+ xti=3 capmod=3 nqsmod=0
+ xpart=1 cf=0 tlev=1
+ tlevc=1
+ dlc=3e-9 llc=-0.039 noimod=2
+ ef=0.874 noia=2.0e+19 noib=1.2e4
+ noic=2.5e-13 em=3.0e+07
+ minr=1e-60 imax=0.01 imelt=0.01

 9: type=n
+ lmin=1.000e-05 - dxln lmax=20.001e-006 wmin=5.0000e-07 - dxwn
+ wmax=1.2000e-06 - dxwn tnom=25.0 version=3.24
+ tox=toxn toxm=4.08e-09 xj=1.6000000e-07
+ nch=3.9000000e17 lln=-1 lwn=1.0000000
+ wln=1.0000000 wwn=1 lint=1.0000000e-08
+ ll=0.00 lw=0.00 lwl=0.00
+ wint=3.0000000e-09 wl=0.00 ww=0.00
+ wwl=0.00 mobmod=1 binunit=2
+ xl= - 0.02e-6 + dxln xw=0.0 + dxwn dwg=0.00
+ dwb=0.00 ldif=9.00e-08
+ hdif=hdifn rsh=rshn rd=0
+ rs=0 vth0=0.4406337 + dvthn
+ wvth0= - 4.2631090e-09 + dwvthn pvth0=0 + dpvthn
+ lvth0=0 + dlvthn k1=dk1n + 0.5610723 wk1=-2.0747230e-08
+ k2=1.1422717e-03 + dk2n lk2=0 + dlk2n wk2=4.9206340e-09
+ k3=0.00 dvt0=0.00 dvt1=0.00
+ dvt2=0.00 dvt0w=0.00 dvt1w=0.00
+ dvt2w=0.00 nlx=0.00 w0=0.00
+ k3b=0.00 vsat=9.0000010e04 + dvsatn
+ wvsat=0 + dwvsatn ua=-9.0664090e-10 wua=1.4309126e-16
+ ub=2.2997995e-18 wub=-1.5411778e-25 uc=1.0721270e-10
+ wuc=-1.4141237e-17 rdsw=drdswn + 1.7000000e02
+ prwb=0.00 prwg=0.00 wr=1.0000000
+ u0=du0n + 3.5199720e-02 pu0=0 + dpu0n wu0=1.0362965e-09 + dwu0n
+ lu0=0 + dlu0n a0=0.3047864 wa0=7.6670510e-08
+ keta=1.0152902e-03 wketa=2.1944087e-10 a1=0.00
+ a2=0.9900000 ags=2.0000000e-02 b0=0.00
+ b1=0.00 voff= - 0.1391954 + dvoffn
+ pvoff=0 + dpvoffn lvoff=0 + dlvoffn
+ wvoff= - 8.6656900e-10 + dwvoffn
+ nfactor=1.0000000 + dnfactorn pnfactor=0 + dpnfactorn
+ wnfactor=0 + dwnfactorn lnfactor=0 + dlnfactorn cit=-1.0000004e-04
+ cdsc=0.00 cdscb=0.00 cdscd=0.00
+ eta0=5.0000000e-05 + deta0n peta0=0 + dpeta0n
+ weta0=0 + dweta0n leta0=0 + dleta0n etab=-5.0000000e-05
+ dsub=0.00 pclm=0.8000001 pdiblc1=1.0000000e-06
+ pdiblc2=7.0000030e-04 pdiblcb=1.0000000e-02 drout=0.00
+ pscbe1=2.0000003e08 pscbe2=1.0000000e-06 pvag=0.00
+ delta=1.0000000e-02 alpha0=0.0 alpha1=0.448150714
+ beta0=11.59263 kt1=-0.2313184 wkt1=1.4490446e-09
+ kt2=-2.9076951e-02 wkt2=1.0605161e-11 at=2.0000000e04
+ ute=-1.6093186 wute=3.8360070e-08 ua1=1.2240000e-09
+ ub1=-1.5012456e-18 wub1=-7.6755530e-27 uc1=-6.8805160e-11
+ wuc1=-1.4706552e-17 kt1l=0.00 prt=0
+ cj=cjn pb=0.6882682 mj=0.3595262
+ cjsw=cjswn pbsw=0.6882682 mjsw=0.2003879
+ cjswg=cjswgn pbswg=0.6882682 mjswg=0.43879
+ cgdo=cgon cgso=cgon tcj=0.001040287
+ tcjsw=0.000645489 tcjswg=0.000645489 tpb=0.001554306
+ tpbsw=0.001554306 tpbswg=0.001554306 js=3.50e-07
+ jsw=1.45e-12 n=1 xti=3
+ capmod=3 nqsmod=0 xpart=1
+ cf=0 tlev=1 tlevc=1
+ dlc=3e-9
+ llc=-0.039 noimod=2 ef=0.874
+ noia=2.0e+19 noib=1.2e4 noic=2.5e-13
+ em=3.0e+07
+ minr=1e-60 imax=0.01 imelt=0.01

 10: type=n
+ lmin=1.200e-06 - dxln lmax=1.000e-05 - dxln wmin=5.0000e-07 - dxwn
+ wmax=1.2000e-06 - dxwn tnom=25.0 version=3.24
+ tox=toxn toxm=4.08e-09 xj=1.6000000e-07
+ nch=3.9000000e17 lln=-1 lwn=1.0000000
+ wln=1.0000000 wwn=1 lint=1.0000000e-08
+ ll=0.00 lw=0.00 lwl=0.00
+ wint=3.0000000e-09 wl=0.00 ww=0.00
+ wwl=0.00 mobmod=1 binunit=2
+ xl= - 0.02e-6 + dxln xw=0.0 + dxwn dwg=0.00
+ dwb=0.00 ldif=9.00e-08
+ hdif=hdifn rsh=rshn rd=0
+ rs=0 vth0=0.4340151 + dvthn
+ lvth0=6.5920480e-08 + dlvthn
+ wvth0= - 3.5444660e-09 + dwvthn
+ pvth0= - 7.1576720e-15 + dpvthn k1=dk1n + 0.5600169
+ lk1=1.0512358e-08 wk1=-1.9283881e-08 pk1=-1.4574950e-14
+ k2=1.6854487e-03 + dk2n lk2= - 5.4100510e-09 + dlk2n
+ wk2=4.6985170e-09 pk2=2.2122807e-15 k3=0.00
+ dvt0=0.00 dvt1=0.00 dvt2=0.00
+ dvt0w=0.00 dvt1w=0.00 dvt2w=0.00
+ nlx=0.00 w0=0.00 k3b=0.00
+ vsat=9.0622610e04 + dvsatn lvsat=-6.2011020e-03
+ wvsat= - 1.2487893e-04 + dwvsatn pvsat=1.2437262e-09
+ ua=-8.8743970e-10 lua=-1.9124487e-16 wua=1.3831368e-16
+ pua=4.7584710e-23 ub=2.2584638e-18 lub=4.1170380e-25
+ wub=-1.4839938e-25 pub=-5.6955330e-32 uc=1.0315766e-10
+ luc=4.0388150e-17 wuc=-1.3213606e-17 puc=-9.2391890e-24
+ rdsw=drdswn + 1.7000000e02 prwb=0.00
+ prwg=0.00 wr=1.0000000 u0=du0n + 3.4827660e-02
+ lu0=3.7057520e-09 + dlu0n wu0=8.6705280e-10 + dwu0n
+ pu0=1.6856667e-15 + dpu0n a0=0.3245910
+ la0=-1.9725388e-07 wa0=8.6726660e-08 pa0=-1.0015934e-13
+ keta=3.8292700e-03 lketa=-2.8027248e-08 wketa=2.8803285e-10
+ pketa=-6.8318020e-16 a1=0.00 a2=0.9900000
+ ags=2.0000000e-02 b0=0.00 b1=0.00
+ voff= - 0.1388337 + dvoffn
+ lvoff= - 3.6022220e-09 + dlvoffn
+ wvoff= - 3.3884450e-10 + dwvoffn
+ pvoff= - 5.2561320e-15 + dpvoffn
+ nfactor=1.0000000 + dnfactorn pnfactor=0 + dpnfactorn
+ wnfactor=0 + dwnfactorn lnfactor=0 + dlnfactorn cit=-1.2672294e-04
+ lcit=2.6616018e-10 wcit=-4.3173710e-14 pcit=4.3027530e-19
+ cdsc=0.00 cdscb=0.00 cdscd=0.00
+ eta0=5.0000000e-05 + deta0n peta0=0 + dpeta0n
+ weta0=0 + dweta0n leta0=0 + dleta0n etab=-5.0000000e-05
+ dsub=0.00 pclm=0.7699873 lpclm=2.9892766e-07
+ wpclm=-1.2487239e-08 ppclm=1.2437180e-13 pdiblc1=1.0000000e-06
+ pdiblc2=3.9681850e-04 lpdiblc2=3.0196912e-09 pdiblcb=1.0000000e-02
+ drout=0.00 pscbe1=1.7363640e08 lpscbe1=2.6258185e02
+ pscbe2=1.0000000e-06 pvag=0.00 delta=1.0000000e-02
+ alpha0=0.0 alpha1=0.448150714 beta0=11.59263
+ kt1=-0.2310088 lkt1=-3.0828107e-09 wkt1=6.6253410e-10
+ pkt1=7.8336390e-15 kt2=-2.8688708e-02 lkt2=-3.8668810e-09
+ wkt2=-8.7256760e-11 pkt2=9.7470440e-16 at=2.0000000e04
+ ute=-1.6080947 lute=-1.2190513e-08 wute=4.1951950e-08
+ pute=-3.5775140e-14 ua1=1.2240000e-09 ub1=-1.5338095e-18
+ lub1=3.2433570e-25 wub1=-5.7682950e-27 pub1=-1.8996434e-32
+ uc1=-7.3164090e-11 luc1=4.3414890e-17 wuc1=-1.6068998e-17
+ puc1=1.3569954e-23 kt1l=0.00 prt=0
+ cj=cjn pb=0.6882682 mj=0.3595262
+ cjsw=cjswn pbsw=0.6882682 mjsw=0.2003879
+ cjswg=cjswgn pbswg=0.6882682 mjswg=0.43879
+ cgdo=cgon cgso=cgon tcj=0.001040287
+ tcjsw=0.000645489 tcjswg=0.000645489 tpb=0.001554306
+ tpbsw=0.001554306 tpbswg=0.001554306 js=3.50e-07
+ jsw=1.45e-12 n=1 xti=3
+ capmod=3 nqsmod=0 xpart=1
+ cf=0 tlev=1 tlevc=1
+ dlc=3e-9
+ llc=-0.039 noimod=2 ef=0.874
+ noia=2.0e+19 noib=1.2e4 noic=2.5e-13
+ em=3.0e+07
+ minr=1e-60 imax=0.01 imelt=0.01

 11: type=n
+ lmin=5.000e-07 - dxln lmax=1.200e-06 - dxln wmin=5.0000e-07 - dxwn
+ wmax=1.2000e-06 - dxwn tnom=25.0 version=3.24
+ tox=toxn toxm=4.08e-09 xj=1.6000000e-07
+ nch=3.9000000e17 lln=-1 lwn=1.0000000
+ wln=1.0000000 wwn=1 lint=1.0000000e-08
+ ll=0.00 lw=0.00 lwl=0.00
+ wint=3.0000000e-09 wl=0.00 ww=0.00
+ wwl=0.00 mobmod=1 binunit=2
+ xl= - 0.02e-6 + dxln xw=0.0 + dxwn dwg=0.00
+ dwb=0.00 ldif=9.00e-08
+ hdif=hdifn rsh=rshn rd=0
+ rs=0 vth0=0.4821278 + dvthn
+ lvth0=1.0109751e-08 + dlvthn
+ wvth0= - 9.2511780e-09 + dwvthn
+ pvth0= - 5.3788820e-16 + dpvthn k1=dk1n + 0.5552615
+ lk1=1.6028618e-08 wk1=-3.8007200e-08 pk1=7.1440980e-15
+ k2=3.5447990e-03 + dk2n lk2= - 7.5668960e-09 + dlk2n
+ wk2=1.0172209e-08 pk2=-4.1372030e-15 k3=0.00
+ dvt0=0.00 dvt1=0.00 dvt2=0.00
+ dvt0w=0.00 dvt1w=0.00 dvt2w=0.00
+ nlx=0.00 w0=0.00 k3b=0.00
+ vsat=8.5937130e04 + dvsatn lvsat=-7.6594880e-04
+ wvsat=9.4352240e-04 + dwvsatn pvsat=4.3808180e-12
+ ua=-1.3333591e-09 lua=3.2602160e-16 wua=2.9360883e-16
+ pua=-1.3255767e-22 ub=2.9690860e-18 lub=-4.1261800e-25
+ wub=-2.4531215e-25 pub=5.5463480e-32 uc=1.6160392e-10
+ luc=-2.7409531e-17 wuc=-1.5428970e-17 puc=-6.6693660e-24
+ rdsw=drdswn + 1.7000000e02 prwb=0.00
+ prwg=0.00 wr=1.0000000 u0=du0n + 3.5811860e-02
+ lu0=2.5640821e-09 + dlu0n wu0=3.2804070e-09 + dwu0n
+ pu0= - 1.1138246e-15 + dpu0n a0=-0.1914371
+ la0=4.0133880e-07 wa0=-9.8314440e-09 pa0=1.1848049e-14
+ keta=-1.7824383e-02 lketa=-2.9090079e-09 wketa=-1.5510503e-09
+ pketa=1.4501565e-15 a1=0.00 a2=0.9900000
+ ags=2.0000000e-02 b0=0.00 b1=0.00
+ voff= - 0.1515625 + dvoffn
+ lvoff=1.1163230e-08 + dlvoffn
+ wvoff= - 7.2883150e-09 + dwvoffn
+ pvoff=2.8052535e-15 + dpvoffn
+ nfactor=1.0000000 + dnfactorn pnfactor=0 + dpnfactorn
+ wnfactor=0 + dwnfactorn lnfactor=0 + dlnfactorn cit=-1.5834050e-04
+ lcit=3.0283653e-10 wcit=5.4312310e-13 pcit=-2.4980728e-19
+ cdsc=0.00 cdscb=0.00 cdscd=0.00
+ eta0=1.7142847e-05 + deta0n peta0=0 + dpeta0n
+ weta0=0 + dweta0n leta0=3.8114300e-11 + dleta0n
+ etab=-1.7142847e-05 letab=-3.8114300e-11 dsub=0.00
+ pclm=0.9444105 lpclm=9.6596760e-08 wpclm=3.1722750e-08
+ ppclm=7.3088240e-14 pdiblc1=1.0000000e-06 pdiblc2=1.1219129e-03
+ lpdiblc2=2.1785818e-09 wpdiblc2=-1.1144895e-10 ppdiblc2=1.2928064e-16
+ pdiblcb=1.0000000e-02 drout=0.00 pscbe1=4.0000010e08
+ pscbe2=1.0000000e-06 pvag=0.00 delta=1.0000000e-02
+ alpha0=0.0 alpha1=0.448150714 beta0=11.59263
+ kt1=-0.2417087 lkt1=9.3290630e-09 wkt1=1.1898274e-08
+ pkt1=-5.1998210e-15 kt2=-3.4342460e-02 lkt2=2.6914670e-09
+ wkt2=2.0987987e-09 pkt2=-1.5611203e-15 at=2.0000000e04
+ ute=-1.8126432 lute=2.2508574e-07 wute=1.8614003e-07
+ pute=-2.0303331e-13 ua1=1.2240000e-09 ub1=-1.6810433e-18
+ lub1=4.9512690e-25 wub1=4.8430470e-25 pub1=-5.8748110e-31
+ uc1=-8.8066520e-11 luc1=6.0701720e-17 wuc1=2.7297169e-17
+ puc1=-3.6734800e-23 kt1l=0.00 prt=0
+ cj=cjn pb=0.6882682 mj=0.3595262
+ cjsw=cjswn pbsw=0.6882682 mjsw=0.2003879
+ cjswg=cjswgn pbswg=0.6882682 mjswg=0.43879
+ cgdo=cgon cgso=cgon tcj=0.001040287
+ tcjsw=0.000645489 tcjswg=0.000645489 tpb=0.001554306
+ tpbsw=0.001554306 tpbswg=0.001554306 js=3.50e-07
+ jsw=1.45e-12 n=1 xti=3
+ capmod=3 nqsmod=0 xpart=1
+ cf=0 tlev=1 tlevc=1
+ dlc=3e-9
+ llc=-0.039 noimod=2 ef=0.874
+ noia=2.0e+19 noib=1.2e4 noic=2.5e-13
+ em=3.0e+07
+ minr=1e-60 imax=0.01 imelt=0.01

 12: type=n
+ lmin=1.8e-007 lmax=5.000e-07 - dxln wmin=5.0000e-07 - dxwn
+ wmax=1.2000e-06 - dxwn tnom=25.0 version=3.24
+ tox=toxn toxm=4.08e-09 xj=1.6000000e-07
+ nch=3.9000000e17 lln=-1 lwn=1.0000000
+ wln=1.0000000 wwn=1 lint=1.0000000e-08
+ ll=0.00 lw=0.00 lwl=0.00
+ wint=3.0000000e-09 wl=0.00 ww=0.00
+ wwl=0.00 mobmod=1 binunit=2
+ xl= - 0.02e-6 + dxln xw=0.0 + dxwn dwg=0.00
+ dwb=0.00 ldif=9.00e-08
+ hdif=hdifn rsh=rshn rd=0
+ rs=0 vth0=0.4891579 + dvthn
+ lvth0=6.8759450e-09 + dlvthn
+ wvth0= - 1.6324883e-08 + dwvthn
+ pvth0=2.7160160e-15 + dpvthn k1=dk1n + 0.4899670
+ lk1=4.6064080e-08 wk1=-1.7855582e-08 pk1=-2.1256446e-15
+ k2=2.9298484e-02 + dk2n lk2= - 1.9413593e-08 + dlk2n
+ wk2=1.6966123e-09 pk2=-2.3842633e-16 k3=0.00
+ dvt0=0.00 dvt1=0.00 dvt2=0.00
+ dvt0w=0.00 dvt1w=0.00 dvt2w=0.00
+ nlx=0.00 w0=0.00 k3b=0.00
+ vsat=8.4736300e04 + dvsatn lvsat=-2.1356932e-04
+ wvsat=9.1813100e-04 + dwvsatn pvsat=1.6060880e-11
+ ua=-5.2740020e-10 lua=-4.4719440e-17 wua=-1.9101984e-17
+ pua=1.1289303e-23 ub=2.0039751e-18 lub=3.1333025e-26
+ wub=-5.1128100e-26 pub=-3.3861180e-32 uc=7.9146470e-11
+ luc=1.0520902e-17 wuc=-9.0127290e-18 puc=-9.6208370e-24
+ rdsw=drdswn + 1.7000000e02 prwb=0.00
+ prwg=0.00 wr=1.0000000 u0=du0n + 3.9805520e-02
+ lu0=7.2699450e-10 + dlu0n
+ wu0= - 4.2684650e-11 + dwu0n pu0=4.1479770e-16 + dpu0n
+ a0=0.5005398 la0=8.3029360e-08 wa0=1.7605426e-07
+ pa0=-7.3659360e-14 keta=-2.7587207e-02 lketa=1.5818911e-09
+ wketa=3.2031690e-09 pketa=-7.3678430e-16 a1=0.00
+ a2=0.9900000 ags=4.0857530e-02 lags=-9.5944640e-09
+ wags=-4.1264700e-09 pags=1.8981756e-15 b0=0.00
+ b1=0.00 voff= - 0.1264125 + dvoffn
+ lvoff= - 4.0576950e-10 + dlvoffn
+ wvoff=3.6377740e-09 + dwvoffn
+ pvoff= - 2.2207474e-15 + dpvoffn
+ nfactor=1.0000000 + dnfactorn pnfactor=0 + dpnfactorn
+ wnfactor=0 + dwnfactorn lnfactor=0 + dlnfactorn cit=2.2317801e-04
+ lcit=1.2733804e-10 wcit=3.0939650e-11 pcit=-1.4232223e-17
+ cdsc=0.00 cdscb=0.00 cdscd=0.00
+ eta0= - 3.1223928e-04 + deta0n
+ leta0=1.8963006e-10 + dleta0n
+ weta0=2.4721704e-11 + dweta0n
+ peta0= - 1.1371991e-17 + dpeta0n etab=1.4101875e-03
+ letab=-6.9468620e-10 wetab=-3.0334849e-11 petab=1.3954016e-17
+ dsub=0.00 pclm=0.9948969 lpclm=7.3373010e-08
+ wpclm=1.9327061e-07 ppclm=-1.2237712e-15 pdiblc1=1.0000000e-06
+ pdiblc2=-4.0132200e-03 lpdiblc2=4.5407440e-09 wpdiblc2=-6.7937070e-10
+ ppdiblc2=3.9052370e-16 pdiblcb=1.0000000e-02 drout=0.00
+ pscbe1=4.0000000e08 pscbe2=1.0000000e-06 pvag=0.00
+ delta=1.0000000e-02 alpha0=0.0 alpha1=0.448150714
+ beta0=11.59263 kt1=-0.2249505 lkt1=1.6202869e-09
+ wkt1=-4.6146780e-09 pkt1=2.3961372e-15 kt2=-2.8312566e-02
+ lkt2=-8.2282570e-11 wkt2=-3.2149460e-09 pkt2=8.8320210e-16
+ at=2.0000000e04 ute=-1.2073984 lute=-5.3326850e-08
+ wute=-3.5053180e-07 pute=4.3835750e-14 ua1=1.2240000e-09
+ ub1=-4.6211320e-19 lub1=-6.5580890e-26 wub1=-1.1442477e-24
+ pub1=1.6165291e-31 uc1=6.0016960e-11 luc1=-7.4166880e-18
+ wuc1=-9.6584590e-17 puc1=2.0250814e-23 kt1l=0.00
+ prt=0 cj=cjn pb=0.6882682
+ mj=0.3595262 cjsw=cjswn pbsw=0.6882682
+ mjsw=0.2003879 cjswg=cjswgn pbswg=0.6882682
+ mjswg=0.43879 cgdo=cgon cgso=cgon
+ tcj=0.001040287 tcjsw=0.000645489 tcjswg=0.000645489
+ tpb=0.001554306 tpbsw=0.001554306 tpbswg=0.001554306
+ js=3.50e-07 jsw=1.45e-12 n=1
+ xti=3 capmod=3 nqsmod=0
+ xpart=1 cf=0 tlev=1
+ tlevc=1
+ dlc=3e-9 llc=-0.039 noimod=2
+ ef=0.874 noia=2.0e+19 noib=1.2e4
+ noic=2.5e-13 em=3.0e+07
+ minr=1e-60 imax=0.01 imelt=0.01

 13: type=n
+ lmin=1.000e-05 - dxln lmax=20.001e-006 wmin=2.2e-007
+ wmax=5.0000e-07 - dxwn tnom=25.0 version=3.24
+ tox=toxn toxm=4.08e-09 xj=1.6000000e-07
+ nch=3.9000000e17 lln=-1 lwn=1.0000000
+ wln=1.0000000 wwn=1 lint=1.0000000e-08
+ ll=0.00 lw=0.00 lwl=0.00
+ wint=3.0000000e-09 wl=0.00 ww=0.00
+ wwl=0.00 mobmod=1 binunit=2
+ xl= - 0.02e-6 + dxln xw=0.0 + dxwn dwg=0.00
+ dwb=0.00 ldif=9.00e-08
+ hdif=hdifn rsh=rshn rd=0
+ rs=0 vth0=0.4632908 + dvthn
+ wvth0= - 1.5455745e-08 + dwvthn pvth0=0 + dpvthn
+ lvth0=0 + dlvthn k1=dk1n + 0.5220979 wk1=-1.4938487e-09
+ k2=1.6542569e-02 + dk2n lk2=0 + dlk2n wk2=-2.6871128e-09
+ k3=0.00 dvt0=0.00 dvt1=0.00
+ dvt2=0.00 dvt0w=0.00 dvt1w=0.00
+ dvt2w=0.00 nlx=0.00 w0=0.00
+ k3b=0.00 vsat=8.9999990e04 + dvsatn
+ wvsat=0 + dwvsatn ua=-5.8606080e-10 wua=-1.5275344e-17
+ ub=1.7266676e-18 wub=1.2900942e-25 uc=7.2522020e-11
+ wuc=2.9959555e-18 rdsw=drdswn + 1.7000000e02
+ prwb=0.00 prwg=0.00 wr=1.0000000
+ u0=du0n + 3.5337420e-02 pu0=0 + dpu0n wu0=9.6827260e-10 + dwu0n
+ lu0=0 + dlu0n a0=0.3529820 wa0=5.2861860e-08
+ keta=2.0642520e-03 wketa=-2.9874625e-10 a1=0.00
+ a2=0.9900000 ags=2.0000000e-02 b0=0.00
+ b1=0.00 voff= - 0.1374522 + dvoffn
+ pvoff=0 + dpvoffn lvoff=0 + dlvoffn
+ wvoff= - 1.7276782e-09 + dwvoffn
+ nfactor=1.0000000 + dnfactorn pnfactor=0 + dpnfactorn
+ wnfactor=0 + dwnfactorn lnfactor=0 + dlnfactorn cit=-9.9999980e-05
+ cdsc=0.00 cdscb=0.00 cdscd=0.00
+ eta0=5.0000000e-05 + deta0n peta0=0 + dpeta0n
+ weta0=0 + dweta0n leta0=0 + dleta0n etab=-5.0000000e-05
+ dsub=0.00 pclm=0.7999999 pdiblc1=1.0000000e-06
+ pdiblc2=6.9999990e-04 pdiblcb=1.0000000e-02 drout=0.00
+ pscbe1=2.0000003e08 pscbe2=1.0000000e-06 pvag=0.00
+ delta=1.0000000e-02 alpha0=0.0 alpha1=0.448150714
+ beta0=11.59263 kt1=-0.2387670 wkt1=5.1286530e-09
+ kt2=-3.6205880e-02 wkt2=3.5322950e-09 at=2.0000000e04
+ ute=-1.5833832 wute=2.5547985e-08 ua1=1.2240000e-09
+ ub1=-1.4270478e-18 wub1=-4.4329310e-26 uc1=-6.3987300e-11
+ wuc1=-1.7086574e-17 kt1l=0.00 prt=0
+ cj=cjn pb=0.6882682 mj=0.3595262
+ cjsw=cjswn pbsw=0.6882682 mjsw=0.2003879
+ cjswg=cjswgn pbswg=0.6882682 mjswg=0.43879
+ cgdo=cgon cgso=cgon tcj=0.001040287
+ tcjsw=0.000645489 tcjswg=0.000645489 tpb=0.001554306
+ tpbsw=0.001554306 tpbswg=0.001554306 js=3.50e-07
+ jsw=1.45e-12 n=1 xti=3
+ capmod=3 nqsmod=0 xpart=1
+ cf=0 tlev=1 tlevc=1
+ dlc=3e-9
+ llc=-0.039 noimod=2 ef=0.874
+ noia=2.0e+19 noib=1.2e4 noic=2.5e-13
+ em=3.0e+07
+ minr=1e-60 imax=0.01 imelt=0.01

 14: type=n
+ lmin=1.200e-06 - dxln lmax=1.000e-05 - dxln wmin=2.2e-007
+ wmax=5.0000e-07 - dxwn tnom=25.0 version=3.24
+ tox=toxn toxm=4.08e-09 xj=1.6000000e-07
+ nch=3.9000000e17 lln=-1 lwn=1.0000000
+ wln=1.0000000 wwn=1 lint=1.0000000e-08
+ ll=0.00 lw=0.00 lwl=0.00
+ wint=3.0000000e-09 wl=0.00 ww=0.00
+ wwl=0.00 mobmod=1 binunit=2
+ xl= - 0.02e-6 + dxln xw=0.0 + dxwn dwg=0.00
+ dwb=0.00 ldif=9.00e-08
+ hdif=hdifn rsh=rshn rd=0
+ rs=0 vth0=0.4576404 + dvthn
+ lvth0=5.6278240e-08 + dlvthn
+ wvth0= - 1.5215344e-08 + dwvthn
+ pvth0= - 2.3944025e-15 + dpvthn k1=dk1n + 0.5284545
+ lk1=-6.3312430e-08 wk1=-3.6920920e-09 pk1=2.1894499e-14
+ k2=1.4454342e-02 + dk2n lk2=2.0798732e-08 + dlk2n
+ wk2=-1.6093152e-09 pk2=-1.0734859e-14 k3=0.00
+ dvt0=0.00 dvt1=0.00 dvt2=0.00
+ dvt0w=0.00 dvt1w=0.00 dvt2w=0.00
+ nlx=0.00 w0=0.00 k3b=0.00
+ vsat=9.0528880e04 + dvsatn lvsat=-5.2677570e-03
+ wvsat= - 7.8579540e-05 + dwvsatn pvsat=7.8265330e-10
+ ua=-5.7313250e-10 lua=-1.2876533e-16 wua=-1.6954039e-17
+ pua=1.6719826e-23 ub=1.6479914e-18 lub=7.8361630e-25
+ wub=1.5317406e-25 pub=-2.4068014e-31 uc=6.5429030e-11
+ luc=7.0646260e-17 wuc=5.4243400e-18 puc=-2.4186704e-23
+ rdsw=drdswn + 1.7000000e02 prwb=0.00
+ prwg=0.00 wr=1.0000000 u0=du0n + 3.4344000e-02
+ lu0=9.8945550e-09 + dlu0n wu0=1.1059835e-09 + dwu0n
+ pu0= - 1.3716021e-15 + dpu0n a0=0.3780467
+ la0=-2.4964379e-07 wa0=6.0319560e-08 pa0=-7.4278730e-14
+ keta=5.1141510e-03 lketa=-3.0377027e-08 wketa=-3.4669910e-10
+ pketa=4.7761250e-16 a1=0.00 a2=0.9900000
+ ags=2.0000000e-02 b0=0.00 b1=0.00
+ voff= - 0.1354716 + dvoffn
+ lvoff= - 1.9727372e-08 + dlvoffn
+ wvoff= - 1.9997353e-09 + dwvoffn
+ pvoff=2.7096929e-15 + dpvoffn
+ nfactor=1.0000000 + dnfactorn pnfactor=0 + dpnfactorn
+ wnfactor=0 + dwnfactorn lnfactor=0 + dlnfactorn cit=-1.2649217e-04
+ lcit=2.6386249e-10 wcit=-1.5715551e-13 pcit=1.5653096e-18
+ cdsc=0.00 cdscb=0.00 cdscd=0.00
+ eta0=5.0000000e-05 + deta0n peta0=0 + dpeta0n
+ weta0=0 + dweta0n leta0=0 + dleta0n etab=-5.0000000e-05
+ dsub=0.00 pclm=0.7606163 lpclm=3.9226100e-07
+ wpclm=-7.8579230e-09 ppclm=7.8265150e-14 pdiblc1=1.0000000e-06
+ pdiblc2=3.9681830e-04 lpdiblc2=3.0196909e-09 pdiblcb=1.0000000e-02
+ drout=0.00 pscbe1=1.7363640e08 lpscbe1=2.6258182e02
+ pscbe2=1.0000000e-06 pvag=0.00 delta=1.0000000e-02
+ alpha0=0.0 alpha1=0.448150714 beta0=11.59263
+ kt1=-0.2407974 lkt1=2.0222748e-08 wkt1=5.4980620e-09
+ pkt1=-3.6793080e-15 kt2=-3.5896250e-02 lkt2=-3.0839447e-09
+ wkt2=3.4732650e-09 pkt2=5.8793360e-16 at=2.0000000e04
+ ute=-1.5785241 lute=-4.8396960e-08 wute=2.7344081e-08
+ pute=-1.7889165e-14 ua1=1.2240000e-09 ub1=-1.4513121e-18
+ lub1=2.4167225e-25 wub1=-4.6522010e-26 pub1=2.1839324e-32
+ uc1=-6.9917860e-11 luc1=5.9068390e-17 wuc1=-1.7672629e-17
+ puc1=5.8371280e-24 kt1l=0.00 prt=0
+ cj=cjn pb=0.6882682 mj=0.3595262
+ cjsw=cjswn pbsw=0.6882682 mjsw=0.2003879
+ cjswg=cjswgn pbswg=0.6882682 mjswg=0.43879
+ cgdo=cgon cgso=cgon tcj=0.001040287
+ tcjsw=0.000645489 tcjswg=0.000645489 tpb=0.001554306
+ tpbsw=0.001554306 tpbswg=0.001554306 js=3.50e-07
+ jsw=1.45e-12 n=1 xti=3
+ capmod=3 nqsmod=0 xpart=1
+ cf=0 tlev=1 tlevc=1
+ dlc=3e-9
+ llc=-0.039 noimod=2 ef=0.874
+ noia=2.0e+19 noib=1.2e4 noic=2.5e-13
+ em=3.0e+07
+ minr=1e-60 imax=0.01 imelt=0.01

 15: type=n
+ lmin=5.000e-07 - dxln lmax=1.200e-06 - dxln wmin=2.2e-007
+ wmax=5.0000e-07 - dxwn tnom=25.0 version=3.24
+ tox=toxn toxm=4.08e-09 xj=1.6000000e-07
+ nch=3.9000000e17 lln=-1 lwn=1.0000000
+ wln=1.0000000 wwn=1 lint=1.0000000e-08
+ ll=0.00 lw=0.00 lwl=0.00
+ wint=3.0000000e-09 wl=0.00 ww=0.00
+ wwl=0.00 mobmod=1 binunit=2
+ xl= - 0.02e-6 + dxln xw=0.0 + dxwn dwg=0.00
+ dwb=0.00 ldif=9.00e-08
+ hdif=hdifn rsh=rshn rd=0
+ rs=0 vth0=0.4985188 + dvthn
+ lvth0=8.8592590e-09 + dlvthn
+ wvth0= - 1.7348324e-08 + dwvthn
+ pvth0=7.9854650e-17 + dpvthn k1=dk1n + 0.4140751
+ lk1=6.9367740e-08 wk1=3.1738890e-08 pk1=-1.9205430e-14
+ k2=5.9564120e-02 + dk2n lk2= - 3.1528607e-08 + dlk2n
+ wk2=-1.7501334e-08 pk2=7.6998830e-15 k3=0.00
+ dvt0=0.00 dvt1=0.00 dvt2=0.00
+ dvt0w=0.00 dvt1w=0.00 dvt2w=0.00
+ nlx=0.00 w0=0.00 k3b=0.00
+ vsat=8.6668210e04 + dvsatn lvsat=-7.8937880e-04
+ wvsat=5.8236690e-04 + dwvsatn pvsat=1.5955267e-11
+ ua=-7.3702990e-10 lua=6.1355590e-17 wua=-9.7776210e-19
+ pua=-1.8126578e-24 ub=2.5777392e-18 lub=-2.9489129e-25
+ wub=-5.1986800e-26 pub=-2.6935000e-33 uc=1.4975288e-10
+ luc=-2.7169401e-17 wuc=-9.5745500e-18 puc=-6.7879900e-24
+ rdsw=drdswn + 1.7000000e02 prwb=0.00
+ prwg=0.00 wr=1.0000000 u0=du0n + 4.4377760e-02
+ lu0= - 1.7446106e-09 + dlu0n
+ wu0= - 9.5114710e-10 + dwu0n pu0=1.0146696e-15 + dpu0n
+ a0=-7.7693450e-02 la0=2.7901473e-07 wa0=-6.6020820e-08
+ pa0=7.2276130e-14 keta=-1.5611105e-02 lketa=-6.3357300e-09
+ wketa=-2.6444102e-09 pketa=3.1429577e-15 a1=0.00
+ a2=0.9900000 ags=2.0000000e-02 b0=0.00
+ b1=0.00 voff= - 0.1694116 + dvoffn
+ lvoff=1.9643004e-08 + dlvoffn
+ wvoff=1.5290980e-09 + dwvoffn
+ pvoff= - 1.3837542e-15 + dpvoffn
+ nfactor=1.0000000 + dnfactorn pnfactor=0 + dpnfactorn
+ wnfactor=0 + dwnfactorn lnfactor=0 + dlnfactorn cit=-1.6124053e-04
+ lcit=3.0417063e-10 wcit=1.9757180e-12 pcit=-9.0883360e-19
+ cdsc=0.00 cdscb=0.00 cdscd=0.00
+ eta0=1.7142866e-05 + deta0n peta0=0 + dpeta0n
+ weta0=0 + dweta0n leta0=3.8114280e-11 + dleta0n
+ etab=-1.7142866e-05 letab=-3.8114280e-11 dsub=0.00
+ pclm=0.9728217 lpclm=1.4610272e-07 wpclm=1.7687656e-08
+ ppclm=4.8632290e-14 pdiblc1=1.0000000e-06 pdiblc2=1.7171376e-03
+ lpdiblc2=1.4881204e-09 wpdiblc2=-4.0549010e-10 ppdiblc2=4.7036850e-16
+ pdiblcb=1.0000000e-02 drout=0.00 pscbe1=4.0000010e08
+ pscbe2=1.0000000e-06 pvag=0.00 delta=1.0000000e-02
+ alpha0=0.0 alpha1=0.448150714 beta0=11.59263
+ kt1=-0.2426658 lkt1=2.2390124e-08 wkt1=1.2371058e-08
+ pkt1=-1.1651986e-14 kt2=-4.0695580e-02 lkt2=2.4832894e-09
+ wkt2=5.2372430e-09 pkt2=-1.4582807e-15 at=2.0000000e04
+ ute=-1.4758356 lute=-1.6751561e-07 wute=1.9757099e-08
+ pute=-9.0882650e-15 ua1=1.2240000e-09 ub1=-4.8661160e-19
+ lub1=-8.7738050e-25 wub1=-1.0574451e-25 pub1=9.0537450e-32
+ uc1=4.8991040e-11 luc1=-7.8865980e-17 wuc1=-4.0409280e-17
+ puc1=3.2211650e-23 kt1l=0.00 prt=0
+ cj=cjn pb=0.6882682 mj=0.3595262
+ cjsw=cjswn pbsw=0.6882682 mjsw=0.2003879
+ cjswg=cjswgn pbswg=0.6882682 mjswg=0.43879
+ cgdo=cgon cgso=cgon tcj=0.001040287
+ tcjsw=0.000645489 tcjswg=0.000645489 tpb=0.001554306
+ tpbsw=0.001554306 tpbswg=0.001554306 js=3.50e-07
+ jsw=1.45e-12 n=1 xti=3
+ capmod=3 nqsmod=0 xpart=1
+ cf=0 tlev=1 tlevc=1
+ dlc=3e-9
+ llc=-0.039 noimod=2 ef=0.874
+ noia=2.0e+19 noib=1.2e4 noic=2.5e-13
+ em=3.0e+07
+ minr=1e-60 imax=0.01 imelt=0.01

 16: type=n
+ lmin=1.8e-007 lmax=5.000e-07 - dxln wmin=2.2e-007
+ wmax=5.0000e-07 - dxwn tnom=25.0 version=3.24
+ tox=toxn toxm=4.08e-09 xj=1.6000000e-07
+ nch=3.9000000e17 lln=-1 lwn=1.0000000
+ wln=1.0000000 wwn=1 lint=1.0000000e-08
+ ll=0.00 lw=0.00 lwl=0.00
+ wint=3.0000000e-09 wl=0.00 ww=0.00
+ wwl=0.00 mobmod=1 binunit=2
+ xl= - 0.02e-6 + dxln xw=0.0 + dxwn dwg=0.00
+ dwb=0.00 ldif=9.00e-08
+ hdif=hdifn rsh=rshn rd=0
+ rs=0 vth0=0.4862920 + dvthn
+ lvth0=1.4483583e-08 + dlvthn
+ wvth0= - 1.4909164e-08 + dwvthn
+ pvth0= - 1.0421574e-15 + dpvthn k1=dk1n + 0.4942783
+ lk1=3.2474290e-08 wk1=-1.9985334e-08 pk1=4.5877080e-15
+ k2=2.3518253e-02 + dk2n lk2= - 1.4947512e-08 + dlk2n
+ wk2=4.5520450e-09 pk2=-2.4446703e-15 k3=0.00
+ dvt0=0.00 dvt1=0.00 dvt2=0.00
+ dvt0w=0.00 dvt1w=0.00 dvt2w=0.00
+ nlx=0.00 w0=0.00 k3b=0.00
+ vsat=8.5400580e04 + dvsatn lvsat=-2.0626588e-04
+ wvsat=5.8998060e-04 + dwvsatn pvsat=1.2452966e-11
+ ua=-6.6143480e-10 lua=2.6581833e-17 wua=4.7111080e-17
+ pua=-2.3933522e-23 ub=2.1301375e-18 lub=-8.8994460e-26
+ wub=-1.1345223e-25 pub=2.5580594e-32 uc=1.2526492e-10
+ luc=-1.5904941e-17 wuc=-3.1795240e-17 puc=3.4335290e-24
+ rdsw=drdswn + 1.7000000e02 prwb=0.00
+ prwg=0.00 wr=1.0000000 u0=du0n + 3.7103500e-02
+ lu0=1.6015452e-09 + dlu0n wu0=1.2921135e-09 + dwu0n
+ pu0= - 1.7230291e-17 + dpu0n a0=0.2707940
+ la0=1.1871046e-07 wa0=2.8954867e-07 pa0=-9.1285820e-14
+ keta=-3.0443965e-02 lketa=4.8738500e-10 wketa=4.6144070e-09
+ pketa=-1.9609824e-16 a1=0.00 a2=0.9900000
+ ags=5.4803800e-02 lags=-1.6009743e-08 wags=-1.1015922e-08
+ pags=5.0673230e-15 b0=0.00 b1=0.00
+ voff= - 0.1182414 + dvoffn
+ lvoff= - 3.8952710e-09 + dlvoffn
+ wvoff= - 3.9877300e-10 + dwvoffn
+ pvoff= - 4.9693370e-16 + dpvoffn
+ nfactor=1.0000000 + dnfactorn pnfactor=0 + dpnfactorn
+ wnfactor=0 + dwnfactorn lnfactor=0 + dlnfactorn cit=2.9138371e-04
+ lcit=9.5963440e-11 wcit=-2.7539906e-12 pcit=1.2668360e-18
+ cdsc=0.00 cdscb=0.00 cdscd=0.00
+ eta0= - 2.6219533e-04 + deta0n peta0=0 + dpeta0n
+ weta0=0 + dweta0n leta0=1.6660984e-10 + dleta0n
+ etab=1.3487812e-03 letab=-6.6643920e-10 dsub=0.00
+ pclm=1.1355271 lpclm=7.1258150e-08 wpclm=1.2379924e-07
+ ppclm=-1.7902992e-16 pdiblc1=1.0000000e-06 pdiblc2=-7.1402370e-03
+ lpdiblc2=5.5625120e-09 wpdiblc2=8.6537500e-10 ppdiblc2=-1.1422951e-16
+ pdiblcb=1.0000000e-02 drout=0.00 pscbe1=4.0000000e08
+ pscbe2=1.0000000e-06 pvag=0.00 delta=1.0000000e-02
+ alpha0=0.0 alpha1=0.448150714 beta0=11.59263
+ kt1=-0.1929406 lkt1=-4.8343960e-10 wkt1=-2.0427562e-08
+ pkt1=3.4353780e-15 kt2=-3.9379210e-02 lkt2=1.8777602e-09
+ wkt2=2.2519782e-09 pkt2=-8.5058880e-17 at=2.0000000e04
+ ute=-1.9466008 lute=4.9036400e-08 wute=1.4634106e-08
+ pute=-6.7316880e-15 ua1=1.2240000e-09 ub1=-3.1027764e-18
+ lub1=3.2605530e-25 wub1=1.6023990e-25 pub1=-3.1815360e-32
+ uc1=-2.4653823e-10 luc1=5.7077470e-17 wuc1=5.4853660e-17
+ puc1=-1.1609298e-23 kt1l=0.00 prt=0
+ cj=cjn pb=0.6882682 mj=0.3595262
+ cjsw=cjswn pbsw=0.6882682 mjsw=0.2003879
+ cjswg=cjswgn pbswg=0.6882682 mjswg=0.43879
+ cgdo=cgon cgso=cgon tcj=0.001040287
+ tcjsw=0.000645489 tcjswg=0.000645489 tpb=0.001554306
+ tpbsw=0.001554306 tpbswg=0.001554306 js=3.50e-07
+ jsw=1.45e-12 n=1 xti=3
+ capmod=3 nqsmod=0 xpart=1
+ cf=0 tlev=1 tlevc=1
+ dlc=3e-9
+ llc=-0.039 noimod=2 ef=0.874
+ noia=2.0e+19 noib=1.2e4 noic=2.5e-13
+ em=3.0e+07
+ minr=1e-60 imax=0.01 imelt=0.01

//  *****************************************************************************************
//
//             *
//                               1.8V CORE PMOS DEVICE MODELS
//             *
//
//             *
//  *****************************************************************************************

     }
model pch bsim3v3  {
 1: type=p
+ lmin=1.000e-05 - dxlp lmax=20.001e-006 wmin=1.0000e-05 - dxwp
+ wmax=900.001e-6 tnom=25.0 version=3.24
+ tox=toxp toxm=4.08e-09 xj=1.7000001e-07
+ nch=3.9000000e17 lln=-1 lwn=1.0000000
+ wln=1.0000000 wwn=1.0000000 lint=1.4999999e-08
+ ll=0.00 lw=0.00 lwl=0.00
+ wint=5.0000000e-09 wl=0.00 ww=0.00
+ wwl=0.00 mobmod=1 binunit=2
+ xl= - 0.02e-6 + dxlp xw=0.0 + dxwp dwg=0.00
+ dwb=0.00 ldif=9.00e-08
+ hdif=hdifp rsh=rshp rd=0
+ rs=0 vth0= - 0.4384811 + dvthp
+ k1=0.5375325 k2=3.5032560e-02 + dk2p lk2=0 + dlk2p
+ pvth0=0 + dpvthp wvth0=0 + dwvthp lvth0=0 + dlvthp
+ k3=0.00 dvt0=0.00 dvt1=0.00
+ dvt2=0.00 dvt0w=0.00 dvt1w=0.00
+ dvt2w=0.00 nlx=0.00 w0=0.00
+ k3b=0.00 vsat=1.4999998e05 + dvsatp
+ wvsat=0 + dwvsatp ua=8.2329400e-10 ub=6.8543220e-19
+ uc=-8.6554110e-11 rdsw=5.3000000e02 prwb=0.00
+ prwg=0.00 wr=1.0000000 u0=1.0865118e-02 + du0p
+ pu0=0 + dpu0p wu0=0 + dwu0p lu0=0 + dlu0p
+ a0=1.0461572 keta=2.6632193e-02 a1=0.00
+ a2=0.4000000 ags=2.0000000e-02 b0=0.00
+ b1=0.00 voff= - 0.1275921 + dvoffp
+ pvoff=0 + dpvoffp wvoff=0 + dwvoffp lvoff=0 + dlvoffp
+ nfactor=1.0000000 + dnfactorp pnfactor=0 + dpnfactorp
+ wnfactor=0 + dwnfactorp lnfactor=0 + dlnfactorp cit=-1.0000000e-04
+ cdsc=0.00 cdscb=0.00 cdscd=0.00
+ eta0=5.0000000e-05 + deta0p peta0=0 + dpeta0p
+ weta0=0 + dweta0p leta0=0 + dleta0p etab=-5.0000000e-05
+ dsub=0.00 pclm=0.6000001 pdiblc1=1.0000000e-06
+ pdiblc2=1.0000003e-03 pdiblcb=1.0000000e-02 drout=0.00
+ pscbe1=1.9999997e08 pscbe2=5.0000000e-07 pvag=0.00
+ delta=1.0000000e-02 alpha0=0.00 alpha1=6.8730453846
+ beta0=22.67827 kt1=-0.2311294 kt2=-2.4339920e-02
+ at=1.0000000e04 ute=-0.8288856 ua1=1.2240000e-09
+ ub1=-1.3928839e-18 uc1=-4.5946700e-12 kt1l=0.00
+ prt=0 cj=cjp pb=0.895226
+ mj=0.4476 cjsw=cjswp pbsw=0.895226
+ mjsw=0.3683619 cjswg=cjswgp pbswg=0.895226
+ mjswg=0.3683619 cgdo=cgop cgso=cgop
+ tcj=0.0009739001 tcjsw=0.0004130718 tcjswg=0.0004130718
+ tpb=0.001572025 tpbsw=0.001572025 tpbswg=0.001572025
+ js=2.50e-07 jsw=1.2e-12 n=1
+ xti=3 capmod=3 nqsmod=0
+ xpart=1 cf=0 tlev=1
+ tlevc=1
+ dlc=2e-9 llc=-0.039 noimod=2
+ ef=1.064 noia=9.5e+18 noib=1.0e5
+ noic=1.4e-12 em=3.0e+07
+ minr=1e-60 imax=0.01 imelt=0.01

 2: type=p
+ lmin=1.200e-06 - dxlp lmax=1.000e-05 - dxlp wmin=1.0000e-05 - dxwp
+ wmax=900.001e-6 tnom=25.0 version=3.24
+ tox=toxp toxm=4.08e-09 xj=1.7000001e-07
+ nch=3.9000000e17 lln=-1 lwn=1.0000000
+ wln=1.0000000 wwn=1.0000000 lint=1.4999999e-08
+ ll=0.00 lw=0.00 lwl=0.00
+ wint=5.0000000e-09 wl=0.00 ww=0.00
+ wwl=0.00 mobmod=1 binunit=2
+ xl= - 0.02e-6 + dxlp xw=0.0 + dxwp dwg=0.00
+ dwb=0.00 ldif=9.00e-08
+ hdif=hdifp rsh=rshp rd=0
+ rs=0 vth0= - 0.4359872 + dvthp
+ pvth0=0 + dpvthp wvth0=0 + dwvthp
+ lvth0= - 2.4814053e-08 + dlvthp k1=0.5356447
+ lk1=1.8783622e-08 k2=3.5584030e-02 + dk2p
+ lk2= - 5.4871720e-09 + dlk2p k3=0.00
+ dvt0=0.00 dvt1=0.00 dvt2=0.00
+ dvt0w=0.00 dvt1w=0.00 dvt2w=0.00
+ nlx=0.00 w0=0.00 k3b=0.00
+ vsat=1.5130680e05 + dvsatp wvsat=0 + dwvsatp
+ lvsat=-1.3002843e-02 ua=8.6253130e-10 lua=-3.9041110e-16
+ ub=6.4019980e-19 lub=4.5006260e-25 uc=-8.8551450e-11
+ luc=1.9873557e-17 rdsw=5.3000000e02 prwb=0.00
+ prwg=0.00 wr=1.0000000 u0=1.0995165e-02 + du0p
+ pu0=0 + dpu0p wu0=0 + dwu0p
+ lu0= - 1.2939689e-09 + dlu0p a0=1.0385712
+ la0=7.5481240e-08 keta=2.6837848e-02 lketa=-2.0462676e-09
+ a1=0.00 a2=0.4000000 ags=2.0000000e-02
+ b0=0.00 b1=0.00
+ voff= - 0.1274002 + dvoffp pvoff=0 + dpvoffp
+ wvoff=0 + dwvoffp lvoff= - 1.9091309e-09 + dlvoffp
+ nfactor=1.0000000 + dnfactorp pnfactor=0 + dpnfactorp
+ wnfactor=0 + dwnfactorp lnfactor=0 + dlnfactorp cit=-1.0000000e-04
+ cdsc=0.00 cdscb=0.00 cdscd=0.00
+ eta0=5.0000000e-05 + deta0p peta0=0 + dpeta0p
+ weta0=0 + dweta0p leta0=0 + dleta0p etab=-5.0000000e-05
+ dsub=0.00 pclm=0.5738637 lpclm=2.6005682e-07
+ pdiblc1=1.0000000e-06 pdiblc2=4.7727270e-04 lpdiblc2=5.2011370e-09
+ pdiblcb=1.0000000e-02 drout=0.00 pscbe1=1.8039768e08
+ lpscbe1=1.9504263e02 pscbe2=5.0000000e-07 pvag=0.00
+ delta=1.0000000e-02 alpha0=0.00 alpha1=6.8730453846
+ beta0=22.67827 kt1=-0.2295883 lkt1=-1.5333228e-08
+ kt2=-2.4031118e-02 lkt2=-3.0725886e-09 at=1.0000000e04
+ ute=-0.8385549 lute=9.6209720e-08 ua1=1.2240000e-09
+ ub1=-1.3977103e-18 lub1=4.8023260e-26 uc1=-6.6949180e-12
+ luc1=2.0897466e-17 kt1l=0.00 prt=0
+ cj=cjp pb=0.895226 mj=0.4476
+ cjsw=cjswp pbsw=0.895226 mjsw=0.3683619
+ cjswg=cjswgp pbswg=0.895226 mjswg=0.3683619
+ cgdo=cgop cgso=cgop tcj=0.0009739001
+ tcjsw=0.0004130718 tcjswg=0.0004130718 tpb=0.001572025
+ tpbsw=0.001572025 tpbswg=0.001572025 js=2.50e-07
+ jsw=1.2e-12 n=1 xti=3
+ capmod=3 nqsmod=0 xpart=1
+ cf=0 tlev=1 tlevc=1
+ dlc=2e-9
+ llc=-0.039 noimod=2 ef=1.064
+ noia=9.5e+18 noib=1.0e5 noic=1.4e-12
+ em=3.0e+07
+ minr=1e-60 imax=0.01 imelt=0.01

 3: type=p
+ lmin=5.000e-07 - dxlp lmax=1.200e-06 - dxlp wmin=1.0000e-05 - dxwp
+ wmax=900.001e-6 tnom=25.0 version=3.24
+ tox=toxp toxm=4.08e-09 xj=1.7000001e-07
+ nch=3.9000000e17 lln=-1 lwn=1.0000000
+ wln=1.0000000 wwn=1.0000000 lint=1.4999999e-08
+ ll=0.00 lw=0.00 lwl=0.00
+ wint=5.0000000e-09 wl=0.00 ww=0.00
+ wwl=0.00 mobmod=1 binunit=2
+ xl= - 0.02e-6 + dxlp xw=0.0 + dxwp dwg=0.00
+ dwb=0.00 ldif=9.00e-08
+ hdif=hdifp rsh=rshp rd=0
+ rs=0 vth0= - 0.4517478 + dvthp
+ pvth0=0 + dpvthp wvth0=0 + dwvthp
+ lvth0= - 6.6894420e-09 + dlvthp k1=0.5405614
+ lk1=1.3129389e-08 k2=3.4901570e-02 + dk2p
+ lk2= - 4.7023350e-09 + dlk2p k3=0.00
+ dvt0=0.00 dvt1=0.00 dvt2=0.00
+ dvt0w=0.00 dvt1w=0.00 dvt2w=0.00
+ nlx=0.00 w0=0.00 k3b=0.00
+ vsat=1.4642853e05 + dvsatp wvsat=0 + dwvsatp
+ lvsat=-7.3928330e-03 ua=5.2669400e-10 lua=-4.1981250e-18
+ ub=1.1734415e-18 lub=-1.6316540e-25 uc=-4.3321150e-11
+ luc=-3.2141290e-17 rdsw=5.3000000e02 prwb=0.00
+ prwg=0.00 wr=1.0000000 u0=1.0224584e-02 + du0p
+ pu0=0 + dpu0p wu0=0 + dwu0p
+ lu0= - 4.0780060e-10 + dlu0p a0=1.0045335
+ la0=1.1462460e-07 keta=3.2152590e-02 lketa=-8.1582250e-09
+ a1=0.00 a2=0.4000000 ags=2.0000000e-02
+ b0=0.00 b1=0.00
+ voff= - 0.1282353 + dvoffp pvoff=0 + dpvoffp
+ wvoff=0 + dwvoffp lvoff= - 9.4878250e-10 + dlvoffp
+ nfactor=1.0000000 + dnfactorp pnfactor=0 + dpnfactorp
+ wnfactor=0 + dwnfactorp lnfactor=0 + dlnfactorp cit=-2.9480609e-04
+ lcit=2.2402701e-10 cdsc=0.00 cdscb=0.00
+ cdscd=0.00 eta0=1.7857143e-05 + deta0p
+ peta0=0 + dpeta0p weta0=0 + dweta0p
+ leta0=3.6964280e-11 + dleta0p etab=-1.7857143e-05
+ letab=-3.6964280e-11 dsub=0.00 pclm=0.6714287
+ lpclm=1.4785704e-07 pdiblc1=1.0000000e-06 pdiblc2=1.7857148e-03
+ lpdiblc2=3.6964280e-09 pdiblcb=1.0000000e-02 drout=0.00
+ pscbe1=3.4999990e08 pscbe2=5.0000000e-07 pvag=0.00
+ delta=1.0000000e-02 alpha0=0.00 alpha1=6.8730453846
+ beta0=22.67827 kt1=-0.2442909 lkt1=1.5747348e-09
+ kt2=-2.7549893e-02 lkt2=9.7400280e-10 at=1.0000000e04
+ ute=-0.7866690 lute=3.6540920e-08 ua1=1.2240000e-09
+ ub1=-1.3827429e-18 lub1=3.0810812e-26 uc1=-1.4394627e-11
+ luc1=2.9752128e-17 kt1l=0.00 prt=0
+ cj=cjp pb=0.895226 mj=0.4476
+ cjsw=cjswp pbsw=0.895226 mjsw=0.3683619
+ cjswg=cjswgp pbswg=0.895226 mjswg=0.3683619
+ cgdo=cgop cgso=cgop tcj=0.0009739001
+ tcjsw=0.0004130718 tcjswg=0.0004130718 tpb=0.001572025
+ tpbsw=0.001572025 tpbswg=0.001572025 js=2.50e-07
+ jsw=1.2e-12 n=1 xti=3
+ capmod=3 nqsmod=0 xpart=1
+ cf=0 tlev=1 tlevc=1
+ dlc=2e-9
+ llc=-0.039 noimod=2 ef=1.064
+ noia=9.5e+18 noib=1.0e5 noic=1.4e-12
+ em=3.0e+07
+ minr=1e-60 imax=0.01 imelt=0.01

 4: type=p
+ lmin=1.8e-007 lmax=5.000e-07 - dxlp wmin=1.0000e-05 - dxwp
+ wmax=900.001e-6 tnom=25.0 version=3.24
+ tox=toxp toxm=4.08e-09 xj=1.7000001e-07
+ nch=3.9000000e17 lln=-1 lwn=1.0000000
+ wln=1.0000000 wwn=1.0000000 lint=1.4999999e-08
+ ll=0.00 lw=0.00 lwl=0.00
+ wint=5.0000000e-09 wl=0.00 ww=0.00
+ wwl=0.00 mobmod=1 binunit=2
+ xl= - 0.02e-6 + dxlp xw=0.0 + dxwp dwg=0.00
+ dwb=0.00 ldif=9.00e-08
+ hdif=hdifp rsh=rshp rd=0
+ rs=0 vth0= - 0.4483009 + dvthp
+ pvth0=0 + dpvthp wvth0=0 + dwvthp
+ lvth0= - 8.2405520e-09 + dlvthp k1=0.5323869
+ lk1=1.6807924e-08 k2=3.7510190e-02 + dk2p
+ lk2= - 5.8762150e-09 + dlk2p k3=0.00
+ dvt0=0.00 dvt1=0.00 dvt2=0.00
+ dvt0w=0.00 dvt1w=0.00 dvt2w=0.00
+ nlx=0.00 w0=0.00 k3b=0.00
+ vsat=1.3081252e05 + dvsatp wvsat=0 + dwvsatp
+ lvsat=-3.6562650e-04 ua=8.7289950e-10 lua=-1.5999061e-16
+ ub=5.3978560e-19 lub=1.2197973e-25 uc=-1.5585878e-10
+ luc=1.8500639e-17 rdsw=5.3000000e02 prwb=0.00
+ prwg=0.00 wr=1.0000000 u0=9.5382440e-03 + du0p
+ pu0=0 + dpu0p wu0=0 + dwu0p
+ lu0= - 9.8947810e-11 + dlu0p a0=1.2232625
+ la0=1.6196543e-08 keta=1.5869336e-02 lketa=-8.3075950e-10
+ a1=0.00 a2=0.4000000 ags=2.0000000e-02
+ b0=0.00 b1=0.00
+ voff= - 0.1302643 + dvoffp pvoff=0 + dpvoffp
+ wvoff=0 + dwvoffp lvoff= - 3.5715920e-11 + dlvoffp
+ nfactor=1.0000000 + dnfactorp pnfactor=0 + dpnfactorp
+ wnfactor=0 + dwnfactorp lnfactor=0 + dlnfactorp cit=-4.0543960e-05
+ lcit=1.0960905e-10 cdsc=0.00 cdscb=0.00
+ cdscd=-8.1250000e-05 lcdscd=3.6562500e-11
+ eta0= - 4.6875020e-04 + deta0p peta0=0 + dpeta0p
+ weta0=0 + dweta0p leta0=2.5593752e-10 + dleta0p
+ etab=1.0775371e-03 letab=-5.2989170e-10 dsub=0.00
+ pclm=0.9102259 lpclm=4.0398300e-08 pdiblc1=1.0000000e-06
+ pdiblc2=7.9687500e-03 lpdiblc2=9.1406260e-10 pdiblcb=1.0000000e-02
+ drout=0.00 pscbe1=3.5000000e08 pscbe2=5.0000000e-07
+ pvag=0.00 delta=1.0000000e-02 alpha0=0.00
+ alpha1=6.8730453846 beta0=22.67827 kt1=-0.2348693
+ lkt1=-2.6650000e-09 kt2=-2.4868647e-02 lkt2=-2.3255770e-10
+ at=1.0000000e04 ute=-0.7090256 lute=1.6013461e-09
+ ua1=1.2240000e-09 ub1=-1.3783631e-18 lub1=2.8839880e-26
+ uc1=6.6936230e-11 luc1=-6.8467590e-18 kt1l=0.00
+ prt=0 cj=cjp pb=0.895226
+ mj=0.4476 cjsw=cjswp pbsw=0.895226
+ mjsw=0.3683619 cjswg=cjswgp pbswg=0.895226
+ mjswg=0.3683619 cgdo=cgop cgso=cgop
+ tcj=0.0009739001 tcjsw=0.0004130718 tcjswg=0.0004130718
+ tpb=0.001572025 tpbsw=0.001572025 tpbswg=0.001572025
+ js=2.50e-07 jsw=1.2e-12 n=1
+ xti=3 capmod=3 nqsmod=0
+ xpart=1 cf=0 tlev=1
+ tlevc=1
+ dlc=2e-9 llc=-0.039 noimod=2
+ ef=1.064 noia=9.5e+18 noib=1.0e5
+ noic=1.4e-12 em=3.0e+07
+ minr=1e-60 imax=0.01 imelt=0.01

 5: type=p
+ lmin=1.000e-05 - dxlp lmax=20.001e-006 wmin=1.2000e-06 - dxwp
+ wmax=1.0000e-05 - dxwp tnom=25.0 version=3.24
+ tox=toxp toxm=4.08e-09 xj=1.7000001e-07
+ nch=3.9000000e17 lln=-1 lwn=1.0000000
+ wln=1.0000000 wwn=1.0000000 lint=1.4999999e-08
+ ll=0.00 lw=0.00 lwl=0.00
+ wint=5.0000000e-09 wl=0.00 ww=0.00
+ wwl=0.00 mobmod=1 binunit=2
+ xl= - 0.02e-6 + dxlp xw=0.0 + dxwp dwg=0.00
+ dwb=0.00 ldif=9.00e-08
+ hdif=hdifp rsh=rshp rd=0
+ rs=0 vth0= - 0.4397694 + dvthp
+ pvth0=0 + dpvthp wvth0=1.2870458e-08 + dwvthp
+ k1=0.5362856 lvth0=0 + dlvthp wk1=1.2456701e-08
+ k2=3.5627170e-02 + dk2p lk2=0 + dlk2p wk2=-5.9401430e-09
+ k3=0.00 dvt0=0.00 dvt1=0.00
+ dvt2=0.00 dvt0w=0.00 dvt1w=0.00
+ dvt2w=0.00 nlx=0.00 w0=0.00
+ k3b=0.00 vsat=1.4999998e05 + dvsatp
+ wvsat=0 + dwvsatp ua=8.0573260e-10 wua=1.7543858e-16
+ ub=7.5080710e-19 wub=-6.5309530e-25 uc=-7.8596050e-11
+ wuc=-7.9500960e-17 rdsw=5.3000000e02 prwb=0.00
+ prwg=0.00 wr=1.0000000 u0=1.0990191e-02 + du0p
+ pu0=0 + dpu0p lu0=0 + dlu0p
+ wu0= - 1.2494747e-09 + dwu0p a0=1.0509492
+ wa0=-4.7871910e-08 keta=2.6001440e-02 wketa=6.3012270e-09
+ a1=0.00 a2=0.4000000 ags=2.0000000e-02
+ b0=0.00 b1=0.00
+ voff= - 0.1274889 + dvoffp pvoff=0 + dpvoffp
+ lvoff=0 + dlvoffp wvoff= - 1.0305298e-09 + dwvoffp
+ nfactor=1.0000000 + dnfactorp pnfactor=0 + dpnfactorp
+ wnfactor=0 + dwnfactorp lnfactor=0 + dlnfactorp cit=-1.0000000e-04
+ cdsc=0.00 cdscb=0.00 cdscd=0.00
+ eta0=5.0000000e-05 + deta0p peta0=0 + dpeta0p
+ weta0=0 + dweta0p leta0=0 + dleta0p etab=-5.0000000e-05
+ dsub=0.00 pclm=0.6000001 pdiblc1=1.0000000e-06
+ pdiblc2=1.0000004e-03 pdiblcb=1.0000000e-02 drout=0.00
+ pscbe1=1.9999997e08 pscbe2=5.0000000e-07 pvag=0.00
+ delta=1.0000000e-02 alpha0=0.00 alpha1=6.8730453846
+ beta0=22.67827 kt1=-0.2319530 wkt1=8.2282740e-09
+ kt2=-2.4488758e-02 wkt2=1.4868883e-09 at=1.0000000e04
+ ute=-0.8394966 wute=1.0600407e-07 ua1=1.2240000e-09
+ ub1=-1.3998005e-18 wub1=6.9097150e-26 uc1=-7.6331580e-12
+ wuc1=3.0354498e-17 kt1l=0.00 prt=0
+ cj=cjp pb=0.895226 mj=0.4476
+ cjsw=cjswp pbsw=0.895226 mjsw=0.3683619
+ cjswg=cjswgp pbswg=0.895226 mjswg=0.3683619
+ cgdo=cgop cgso=cgop tcj=0.0009739001
+ tcjsw=0.0004130718 tcjswg=0.0004130718 tpb=0.001572025
+ tpbsw=0.001572025 tpbswg=0.001572025 js=2.50e-07
+ jsw=1.2e-12 n=1 xti=3
+ capmod=3 nqsmod=0 xpart=1
+ cf=0 tlev=1 tlevc=1
+ dlc=2e-9
+ llc=-0.039 noimod=2 ef=1.064
+ noia=9.5e+18 noib=1.0e5 noic=1.4e-12
+ em=3.0e+07
+ minr=1e-60 imax=0.01 imelt=0.01

 6: type=p
+ lmin=1.200e-06 - dxlp lmax=1.000e-05 - dxlp wmin=1.2000e-06 - dxwp
+ wmax=1.0000e-05 - dxwp tnom=25.0 version=3.24
+ tox=toxp toxm=4.08e-09 xj=1.7000001e-07
+ nch=3.9000000e17 lln=-1 lwn=1.0000000
+ wln=1.0000000 wwn=1.0000000 lint=1.4999999e-08
+ ll=0.00 lw=0.00 lwl=0.00
+ wint=5.0000000e-09 wl=0.00 ww=0.00
+ wwl=0.00 mobmod=1 binunit=2
+ xl= - 0.02e-6 + dxlp xw=0.0 + dxwp dwg=0.00
+ dwb=0.00 ldif=9.00e-08
+ hdif=hdifp rsh=rshp rd=0
+ rs=0 vth0= - 0.4373293 + dvthp
+ lvth0= - 2.4279869e-08 + dlvthp
+ wvth0=1.3406786e-08 + dwvthp
+ pvth0= - 5.3364720e-15 + dpvthp k1=0.5344580
+ lk1=1.8184398e-08 wk1=1.1855070e-08 pk1=5.9862430e-15
+ k2=3.6157890e-02 + dk2p lk2= - 5.2806350e-09 + dlk2p
+ wk2=-5.7327760e-09 pk2=-2.0633070e-15 k3=0.00
+ dvt0=0.00 dvt1=0.00 dvt2=0.00
+ dvt0w=0.00 dvt1w=0.00 dvt2w=0.00
+ nlx=0.00 w0=0.00 k3b=0.00
+ vsat=1.5130680e05 + dvsatp wvsat=0 + dwvsatp
+ lvsat=-1.3002842e-02 ua=8.4528650e-10 lua=-3.9356080e-16
+ wua=1.7227619e-16 pua=3.1465633e-23 ub=7.0840050e-19
+ lub=4.2194590e-25 wub=-6.8132500e-25 pub=2.8088595e-31
+ uc=-8.0493860e-11 luc=1.8883157e-17 wuc=-8.0495330e-17
+ puc=9.8941000e-24 rdsw=5.3000000e02 prwb=0.00
+ prwg=0.00 wr=1.0000000 u0=1.1121400e-02 + du0p
+ lu0= - 1.3055237e-09 + dlu0p
+ wu0= - 1.2610760e-09 + dwu0p pu0=1.1543239e-16 + dpu0p
+ a0=1.0440365 la0=6.8781320e-08 wa0=-5.4598760e-08
+ pa0=6.6932220e-14 keta=2.6128704e-02 lketa=-1.2662711e-09
+ wketa=7.0843590e-09 pketa=-7.7921670e-15 a1=0.00
+ a2=0.4000000 ags=2.0000000e-02 b0=0.00
+ b1=0.00 voff= - 0.1273414 + dvoffp
+ lvoff= - 1.4683624e-09 + dlvoffp
+ wvoff= - 5.8798940e-10 + dwvoffp
+ pvoff= - 4.4032780e-15 + dpvoffp
+ nfactor=1.0000000 + dnfactorp pnfactor=0 + dpnfactorp
+ wnfactor=0 + dwnfactorp lnfactor=0 + dlnfactorp cit=-1.0000000e-04
+ cdsc=0.00 cdscb=0.00 cdscd=0.00
+ eta0=5.0000000e-05 + deta0p peta0=0 + dpeta0p
+ weta0=0 + dweta0p leta0=0 + dleta0p etab=-5.0000000e-05
+ dsub=0.00 pclm=0.5738637 lpclm=2.6005682e-07
+ pdiblc1=1.0000000e-06 pdiblc2=4.7727280e-04 lpdiblc2=5.2011370e-09
+ pdiblcb=1.0000000e-02 drout=0.00 pscbe1=1.8039770e08
+ lpscbe1=1.9504262e02 pscbe2=5.0000000e-07 pvag=0.00
+ delta=1.0000000e-02 alpha0=0.00 alpha1=6.8730453846
+ beta0=22.67827 kt1=-0.2303147 lkt1=-1.6300865e-08
+ wkt1=7.2567470e-09 pkt1=9.6666970e-15 kt2=-2.4155809e-02
+ lkt2=-3.3128360e-09 wkt2=1.2456750e-09 pkt2=2.4000725e-15
+ at=1.0000000e04 ute=-0.8492097 lute=9.6644970e-08
+ wute=1.0644106e-07 pute=-4.3481010e-15 ua1=1.2240000e-09
+ ub1=-1.4052706e-18 lub1=5.4427270e-26 wub1=7.5526920e-26
+ pub1=-6.3976190e-32 uc1=-9.4700360e-12 luc1=1.8276951e-17
+ wuc1=2.7723443e-17 puc1=2.6178952e-23 kt1l=0.00
+ prt=0 cj=cjp pb=0.895226
+ mj=0.4476 cjsw=cjswp pbsw=0.895226
+ mjsw=0.3683619 cjswg=cjswgp pbswg=0.895226
+ mjswg=0.3683619 cgdo=cgop cgso=cgop
+ tcj=0.0009739001 tcjsw=0.0004130718 tcjswg=0.0004130718
+ tpb=0.001572025 tpbsw=0.001572025 tpbswg=0.001572025
+ js=2.50e-07 jsw=1.2e-12 n=1
+ xti=3 capmod=3 nqsmod=0
+ xpart=1 cf=0 tlev=1
+ tlevc=1
+ dlc=2e-9 llc=-0.039 noimod=2
+ ef=1.064 noia=9.5e+18 noib=1.0e5
+ noic=1.4e-12 em=3.0e+07
+ minr=1e-60 imax=0.01 imelt=0.01

 7: type=p
+ lmin=5.000e-07 - dxlp lmax=1.200e-06 - dxlp wmin=1.2000e-06 - dxwp
+ wmax=1.0000e-05 - dxwp tnom=25.0 version=3.24
+ tox=toxp toxm=4.08e-09 xj=1.7000001e-07
+ nch=3.9000000e17 lln=-1 lwn=1.0000000
+ wln=1.0000000 wwn=1.0000000 lint=1.4999999e-08
+ ll=0.00 lw=0.00 lwl=0.00
+ wint=5.0000000e-09 wl=0.00 ww=0.00
+ wwl=0.00 mobmod=1 binunit=2
+ xl= - 0.02e-6 + dxlp xw=0.0 + dxwp dwg=0.00
+ dwb=0.00 ldif=9.00e-08
+ hdif=hdifp rsh=rshp rd=0
+ rs=0 vth0= - 0.4527619 + dvthp
+ lvth0= - 6.5323870e-09 + dlvthp
+ wvth0=1.0130710e-08 + dwvthp
+ pvth0= - 1.5689828e-15 + dpvthp k1=0.5429910
+ lk1=8.3714530e-09 wk1=-2.4271484e-08 pk1=4.7531780e-14
+ k2=3.4362420e-02 + dk2p lk2= - 3.2158540e-09 + dlk2p
+ wk2=5.3860310e-09 pk2=-1.4849934e-14 k3=0.00
+ dvt0=0.00 dvt1=0.00 dvt2=0.00
+ dvt0w=0.00 dvt1w=0.00 dvt2w=0.00
+ nlx=0.00 w0=0.00 k3b=0.00
+ vsat=1.4642853e05 + dvsatp wvsat=0 + dwvsatp
+ lvsat=-7.3928330e-03 ua=4.7628350e-10 lua=3.0792715e-17
+ wua=5.0360140e-16 pua=-3.4955840e-22 ub=1.2463172e-18
+ lub=-1.9665828e-25 wub=-7.2802750e-25 pub=3.3459380e-31
+ uc=-3.1899420e-11 luc=-3.7000450e-17 wuc=-1.1410304e-16
+ puc=4.8542970e-23 rdsw=5.3000000e02 prwb=0.00
+ prwg=0.00 wr=1.0000000 u0=1.0286789e-02 + du0p
+ lu0= - 3.4572260e-10 + dlu0p
+ wu0= - 6.2143110e-10 + dwu0p
+ pu0= - 6.2015920e-16 + dpu0p a0=0.9932752
+ la0=1.2715688e-07 wa0=1.1247056e-07 pa0=-1.2519753e-13
+ keta=3.2315410e-02 lketa=-8.3809840e-09 wketa=-1.6265284e-09
+ pketa=2.2253538e-15 a1=0.00 a2=0.4000000
+ ags=2.0000000e-02 b0=0.00 b1=0.00
+ voff= - 0.1274479 + dvoffp
+ lvoff= - 1.3458795e-09 + dlvoffp
+ wvoff= - 7.8664910e-09 + dwvoffp
+ pvoff=3.9669990e-15 + dpvoffp
+ nfactor=1.0000000 + dnfactorp pnfactor=0 + dpnfactorp
+ wnfactor=0 + dwnfactorp lnfactor=0 + dlnfactorp cit=-2.9301620e-04
+ lcit=2.2196864e-10 wcit=-1.7881040e-11 pcit=2.0563189e-17
+ cdsc=0.00 cdscb=0.00 cdscd=0.00
+ eta0=1.7857139e-05 + deta0p peta0=0 + dpeta0p
+ weta0=0 + dweta0p leta0=3.6964290e-11 + dleta0p
+ etab=-1.7857139e-05 letab=-3.6964290e-11 dsub=0.00
+ pclm=0.6714287 lpclm=1.4785702e-07 pdiblc1=1.0000000e-06
+ pdiblc2=1.7857144e-03 lpdiblc2=3.6964280e-09 pdiblcb=1.0000000e-02
+ drout=0.00 pscbe1=3.4999990e08 pscbe2=5.0000000e-07
+ pvag=0.00 delta=1.0000000e-02 alpha0=0.00
+ alpha1=6.8730453846 beta0=22.67827 kt1=-0.2459144
+ lkt1=1.6387112e-09 wkt1=1.6218328e-08 pkt1=-6.3912370e-16
+ kt2=-2.7846618e-02 lkt2=9.3159460e-10 wkt2=2.9642964e-09
+ pkt2=4.2365790e-16 at=1.0000000e04 ute=-0.7951261
+ lute=3.4448810e-08 wute=8.4486070e-08 pute=2.0900147e-14
+ ua1=1.2240000e-09 ub1=-1.3967723e-18 lub1=4.4654300e-26
+ wub1=1.4015321e-25 pub1=-1.3829640e-31 uc1=-2.3838735e-11
+ luc1=3.4800940e-17 wuc1=9.4346610e-17 puc1=-5.0437680e-23
+ kt1l=0.00 prt=0 cj=cjp
+ pb=0.895226 mj=0.4476 cjsw=cjswp
+ pbsw=0.895226 mjsw=0.3683619 cjswg=cjswgp
+ pbswg=0.895226 mjswg=0.3683619 cgdo=cgop
+ cgso=cgop tcj=0.0009739001 tcjsw=0.0004130718
+ tcjswg=0.0004130718 tpb=0.001572025 tpbsw=0.001572025
+ tpbswg=0.001572025 js=2.50e-07 jsw=1.2e-12
+ n=1 xti=3 capmod=3
+ nqsmod=0 xpart=1 cf=0
+ tlev=1 tlevc=1
+ dlc=2e-9 llc=-0.039
+ noimod=2 ef=1.064 noia=9.5e+18
+ noib=1.0e5 noic=1.4e-12 em=3.0e+07
+ minr=1e-60 imax=0.01 imelt=0.01

 8: type=p
+ lmin=1.8e-007 lmax=5.000e-07 - dxlp wmin=1.2000e-06 - dxwp
+ wmax=1.0000e-05 - dxwp tnom=25.0 version=3.24
+ tox=toxp toxm=4.08e-09 xj=1.7000001e-07
+ nch=3.9000000e17 lln=-1 lwn=1.0000000
+ wln=1.0000000 wwn=1.0000000 lint=1.4999999e-08
+ ll=0.00 lw=0.00 lwl=0.00
+ wint=5.0000000e-09 wl=0.00 ww=0.00
+ wwl=0.00 mobmod=1 binunit=2
+ xl= - 0.02e-6 + dxlp xw=0.0 + dxwp dwg=0.00
+ dwb=0.00 ldif=9.00e-08
+ hdif=hdifp rsh=rshp rd=0
+ rs=0 vth0= - 0.4492160 + dvthp
+ lvth0= - 8.1280260e-09 + dlvthp
+ wvth0=9.1421640e-09 + dwvthp
+ pvth0= - 1.1241356e-15 + dpvthp k1=0.5203763
+ lk1=1.8548040e-08 wk1=1.1998529e-07 pk1=-1.7383759e-14
+ k2=4.1939260e-02 + dk2p lk2= - 6.6254260e-09 + dlk2p
+ wk2=-4.4246340e-08 pk2=7.4846270e-15 k3=0.00
+ dvt0=0.00 dvt1=0.00 dvt2=0.00
+ dvt0w=0.00 dvt1w=0.00 dvt2w=0.00
+ nlx=0.00 w0=0.00 k3b=0.00
+ vsat=1.3081252e05 + dvsatp wvsat=0 + dwvsatp
+ lvsat=-3.6562710e-04 ua=9.3578630e-10 lua=-1.7598350e-16
+ wua=-6.2823680e-16 pua=1.5976873e-22 ub=5.0912570e-19
+ lub=1.3507784e-25 wub=3.0629255e-25 pub=-1.3085017e-31
+ uc=-1.5731644e-10 luc=1.9437196e-17 wuc=1.4561782e-17
+ puc=-9.3561970e-24 rdsw=5.3000000e02 prwb=0.00
+ prwg=0.00 wr=1.0000000 u0=9.7957610e-03 + du0p
+ lu0= - 1.2475933e-10 + dlu0p
+ wu0= - 2.5725782e-09 + dwu0p pu0=2.5785697e-16 + dpu0p
+ a0=1.2640158 la0=5.3236360e-09 wa0=-4.0712480e-07
+ pa0=1.0862038e-13 keta=1.4996022e-02 lketa=-5.8725920e-10
+ wketa=8.7244130e-09 pketa=-2.4325694e-15 a1=0.00
+ a2=0.4000000 ags=1.9847063e-02 lags=6.8821010e-11
+ wags=1.5278273e-09 pags=-6.8752220e-16 b0=0.00
+ b1=0.00 voff= - 0.1308021 + dvoffp
+ lvoff=1.6353495e-10 + dlvoffp
+ wvoff=5.3724310e-09 + dwvoffp
+ pvoff= - 1.9905158e-15 + dpvoffp
+ nfactor=1.0000000 + dnfactorp pnfactor=0 + dpnfactorp
+ wnfactor=0 + dwnfactorp lnfactor=0 + dlnfactorp cit=-6.0918400e-05
+ lcit=1.1752459e-10 wcit=2.0354016e-10 pcit=-7.9076310e-17
+ cdsc=0.00 cdscb=0.00 cdscd=-8.2898130e-05
+ lcdscd=3.7304140e-11 wcdscd=1.6464351e-11 pcdscd=-7.4089540e-18
+ eta0= - 4.6875020e-04 + deta0p peta0=0 + dpeta0p
+ weta0=0 + dweta0p leta0=2.5593752e-10 + dleta0p
+ etab=1.1323938e-03 letab=-5.5457720e-10 wetab=-5.4801690e-10
+ petab=2.4660761e-16 dsub=0.00 pclm=0.9107697
+ lpclm=4.0153610e-08 wpclm=-5.4322380e-09 ppclm=2.4445072e-15
+ pdiblc1=1.0000000e-06 pdiblc2=7.9878660e-03 lpdiblc2=9.0546000e-10
+ wpdiblc2=-1.9097854e-10 ppdiblc2=8.5940170e-17 pdiblcb=1.0000000e-02
+ drout=0.00 pscbe1=3.5000000e08 pscbe2=5.0000000e-07
+ pvag=0.00 delta=1.0000000e-02 alpha0=0.00
+ alpha1=6.8730453846 beta0=22.67827 kt1=-0.2367561
+ lkt1=-2.4825255e-09 wkt1=1.8848993e-08 pkt1=-1.8229216e-15
+ kt2=-2.5532207e-02 lkt2=-1.0989117e-10 wkt2=6.6289560e-09
+ pkt2=-1.2254391e-15 at=1.0000000e04 ute=-0.7199521
+ lute=6.2052350e-10 wute=1.0915658e-07 pute=9.7984170e-15
+ ua1=1.2240000e-09 ub1=-1.3554493e-18 lub1=2.6058948e-26
+ wub1=-2.2890885e-25 pub1=2.7781507e-32 uc1=7.0516520e-11
+ luc1=-7.6589150e-18 wuc1=-3.5766990e-17 puc1=8.1134340e-24
+ kt1l=0.00 prt=0 cj=cjp
+ pb=0.895226 mj=0.4476 cjsw=cjswp
+ pbsw=0.895226 mjsw=0.3683619 cjswg=cjswgp
+ pbswg=0.895226 mjswg=0.3683619 cgdo=cgop
+ cgso=cgop tcj=0.0009739001 tcjsw=0.0004130718
+ tcjswg=0.0004130718 tpb=0.001572025 tpbsw=0.001572025
+ tpbswg=0.001572025 js=2.50e-07 jsw=1.2e-12
+ n=1 xti=3 capmod=3
+ nqsmod=0 xpart=1 cf=0
+ tlev=1 tlevc=1
+ dlc=2e-9 llc=-0.039
+ noimod=2 ef=1.064 noia=9.5e+18
+ noib=1.0e5 noic=1.4e-12 em=3.0e+07
+ minr=1e-60 imax=0.01 imelt=0.01

 9: type=p
+ lmin=1.000e-05 - dxlp lmax=20.001e-006 wmin=5.0000e-07 - dxwp
+ wmax=1.2000e-06 - dxwp tnom=25.0 version=3.24
+ tox=toxp toxm=4.08e-09 xj=1.7000001e-07
+ nch=3.9000000e17 lln=-1 lwn=1.0000000
+ wln=1.0000000 wwn=1.0000000 lint=1.4999999e-08
+ ll=0.00 lw=0.00 lwl=0.00
+ wint=5.0000000e-09 wl=0.00 ww=0.00
+ wwl=0.00 mobmod=1 binunit=2
+ xl= - 0.02e-6 + dxlp xw=0.0 + dxwp dwg=0.00
+ dwb=0.00 ldif=9.00e-08
+ hdif=hdifp rsh=rshp rd=0
+ rs=0 vth0= - 0.4286388 + dvthp
+ pvth0=0 + dpvthp wvth0= - 3.7506110e-10 + dwvthp
+ k1=0.5449055 lvth0=0 + dlvthp wk1=2.1990281e-09
+ k2=3.3849380e-02 + dk2p lk2=0 + dlk2p wk2=-3.8245820e-09
+ k3=0.00 dvt0=0.00 dvt1=0.00
+ dvt2=0.00 dvt0w=0.00 dvt1w=0.00
+ dvt2w=0.00 nlx=0.00 w0=0.00
+ k3b=0.00 vsat=1.4999998e05 + dvsatp
+ wvsat=0 + dwvsatp ua=1.0698959e-09 wua=-1.3891575e-16
+ ub=3.0837888e-19 wub=-1.2660565e-25 uc=-1.1659398e-10
+ wuc=-3.4283420e-17 rdsw=5.3000000e02 prwb=0.00
+ prwg=0.00 wr=1.0000000 u0=1.0132165e-02 + du0p
+ pu0=0 + dpu0p lu0=0 + dlu0p
+ wu0= - 2.2842360e-10 + dwu0p a0=0.9810578
+ wa0=3.5298850e-08 keta=3.2175460e-02 wketa=-1.0458587e-09
+ a1=0.00 a2=0.4000000 ags=2.0000000e-02
+ b0=0.00 b1=0.00
+ voff= - 0.1280100 + dvoffp pvoff=0 + dpvoffp
+ lvoff=0 + dlvoffp wvoff= - 4.1052410e-10 + dwvoffp
+ nfactor=1.0000000 + dnfactorp pnfactor=0 + dpnfactorp
+ wnfactor=0 + dwnfactorp lnfactor=0 + dlnfactorp cit=-1.0000000e-04
+ cdsc=0.00 cdscb=0.00 cdscd=0.00
+ eta0=5.0000000e-05 + deta0p peta0=0 + dpeta0p
+ weta0=0 + dweta0p leta0=0 + dleta0p etab=-5.0000000e-05
+ dsub=0.00 pclm=0.6000000 pdiblc1=1.0000000e-06
+ pdiblc2=9.9999980e-04 pdiblcb=1.0000000e-02 drout=0.00
+ pscbe1=1.9999997e08 pscbe2=5.0000000e-07 pvag=0.00
+ delta=1.0000000e-02 alpha0=0.00 alpha1=6.8730453846
+ beta0=22.67827 kt1=-0.2307052 wkt1=6.7433300e-09
+ kt2=-2.3348080e-02 wkt2=1.2948118e-10 at=1.0000000e04
+ ute=-0.7480742 wute=-2.7886795e-09 ua1=1.2240000e-09
+ ub1=-1.3711068e-18 wub1=3.4951630e-26 uc1=1.6263793e-12
+ wuc1=1.9335648e-17 kt1l=0.00 prt=0
+ cj=cjp pb=0.895226 mj=0.4476
+ cjsw=cjswp pbsw=0.895226 mjsw=0.3683619
+ cjswg=cjswgp pbswg=0.895226 mjswg=0.3683619
+ cgdo=cgop cgso=cgop tcj=0.0009739001
+ tcjsw=0.0004130718 tcjswg=0.0004130718 tpb=0.001572025
+ tpbsw=0.001572025 tpbswg=0.001572025 js=2.50e-07
+ jsw=1.2e-12 n=1 xti=3
+ capmod=3 nqsmod=0 xpart=1
+ cf=0 tlev=1 tlevc=1
+ dlc=2e-9
+ llc=-0.039 noimod=2 ef=1.064
+ noia=9.5e+18 noib=1.0e5 noic=1.4e-12
+ em=3.0e+07
+ minr=1e-60 imax=0.01 imelt=0.01

 10: type=p
+ lmin=1.200e-06 - dxlp lmax=1.000e-05 - dxlp wmin=5.0000e-07 - dxwp
+ wmax=1.2000e-06 - dxwp tnom=25.0 version=3.24
+ tox=toxp toxm=4.08e-09 xj=1.7000001e-07
+ nch=3.9000000e17 lln=-1 lwn=1.0000000
+ wln=1.0000000 wwn=1.0000000 lint=1.4999999e-08
+ ll=0.00 lw=0.00 lwl=0.00
+ wint=5.0000000e-09 wl=0.00 ww=0.00
+ wwl=0.00 mobmod=1 binunit=2
+ xl= - 0.02e-6 + dxlp xw=0.0 + dxwp dwg=0.00
+ dwb=0.00 ldif=9.00e-08
+ hdif=hdifp rsh=rshp rd=0
+ rs=0 vth0= - 0.4245711 + dvthp
+ lvth0= - 4.0472930e-08 + dlvthp
+ wvth0= - 1.7753915e-09 + dwvthp
+ pvth0=1.3933270e-14 + dpvthp k1=0.5429414
+ lk1=1.9542425e-08 wk1=1.7598129e-09 pk1=4.3701940e-15
+ k2=3.4365640e-02 + dk2p lk2= - 5.1367190e-09 + dlk2p
+ wk2=-3.6000030e-09 pk2=-2.2345663e-15 k3=0.00
+ dvt0=0.00 dvt1=0.00 dvt2=0.00
+ dvt0w=0.00 dvt1w=0.00 dvt2w=0.00
+ nlx=0.00 w0=0.00 k3b=0.00
+ vsat=1.5130680e05 + dvsatp wvsat=0 + dwvsatp
+ lvsat=-1.3002842e-02 ua=1.1283389e-09 lua=-5.8150770e-16
+ wua=-1.6455617e-16 pua=2.5512236e-22 ub=1.9594849e-19
+ lub=1.1186816e-24 wub=-7.1507210e-26 pub=-5.4822940e-31
+ uc=-1.2405904e-10 luc=7.4277340e-17 wuc=-2.8652769e-17
+ puc=-5.6024980e-23 rdsw=5.3000000e02 prwb=0.00
+ prwg=0.00 wr=1.0000000 u0=1.0228163e-02 + du0p
+ lu0= - 9.5517820e-10 + dlu0p
+ wu0= - 1.9812424e-10 + dwu0p
+ pu0= - 3.0147877e-16 + dpu0p a0=0.9688198
+ la0=1.2176828e-07 wa0=3.4909120e-08 pa0=3.8777300e-15
+ keta=3.2820440e-02 lketa=-6.4175870e-09 wketa=-8.7881330e-10
+ pketa=-1.6621007e-15 a1=0.00 a2=0.4000000
+ ags=2.0000000e-02 b0=0.00 b1=0.00
+ voff= - 0.1269095 + dvoffp
+ lvoff= - 1.0948965e-08 + dlvoffp
+ wvoff= - 1.1018445e-09 + dwvoffp
+ pvoff=6.8786400e-15 + dpvoffp
+ nfactor=1.0000000 + dnfactorp pnfactor=0 + dpnfactorp
+ wnfactor=0 + dwnfactorp lnfactor=0 + dlnfactorp cit=-1.0000000e-04
+ cdsc=0.00 cdscb=0.00 cdscd=0.00
+ eta0=5.0000000e-05 + deta0p peta0=0 + dpeta0p
+ weta0=0 + dweta0p leta0=0 + dleta0p etab=-5.0000000e-05
+ dsub=0.00 pclm=0.5738636 lpclm=2.6005682e-07
+ pdiblc1=1.0000000e-06 pdiblc2=4.7727220e-04 lpdiblc2=5.2011370e-09
+ pdiblcb=1.0000000e-02 drout=0.00 pscbe1=1.8039768e08
+ lpscbe1=1.9504263e02 pscbe2=5.0000000e-07 pvag=0.00
+ delta=1.0000000e-02 alpha0=0.00 alpha1=6.8730453846
+ beta0=22.67827 kt1=-0.2296747 lkt1=-1.0252924e-08
+ wkt1=6.4951250e-09 pkt1=2.4696450e-15 kt2=-2.3308404e-02
+ lkt2=-3.9477850e-10 wkt2=2.3726165e-10 pkt2=-1.0724159e-15
+ at=1.0000000e04 ute=-0.7541180 lute=6.0136590e-08
+ wute=-6.7180150e-09 pute=3.9096880e-14 ua1=1.2240000e-09
+ ub1=-1.3784619e-18 lub1=7.3183410e-26 wub1=4.3624580e-26
+ pub1=-8.6295970e-32 uc1=-1.1517035e-12 luc1=2.7641896e-17
+ wuc1=1.7824627e-17 puc1=1.5034668e-23 kt1l=0.00
+ prt=0 cj=cjp pb=0.895226
+ mj=0.4476 cjsw=cjswp pbsw=0.895226
+ mjsw=0.3683619 cjswg=cjswgp pbswg=0.895226
+ mjswg=0.3683619 cgdo=cgop cgso=cgop
+ tcj=0.0009739001 tcjsw=0.0004130718 tcjswg=0.0004130718
+ tpb=0.001572025 tpbsw=0.001572025 tpbswg=0.001572025
+ js=2.50e-07 jsw=1.2e-12 n=1
+ xti=3 capmod=3 nqsmod=0
+ xpart=1 cf=0 tlev=1
+ tlevc=1
+ dlc=2e-9 llc=-0.039 noimod=2
+ ef=1.064 noia=9.5e+18 noib=1.0e5
+ noic=1.4e-12 em=3.0e+07
+ minr=1e-60 imax=0.01 imelt=0.01

 11: type=p
+ lmin=5.000e-07 - dxlp lmax=1.200e-06 - dxlp wmin=5.0000e-07 - dxwp
+ wmax=1.2000e-06 - dxwp tnom=25.0 version=3.24
+ tox=toxp toxm=4.08e-09 xj=1.7000001e-07
+ nch=3.9000000e17 lln=-1 lwn=1.0000000
+ wln=1.0000000 wwn=1.0000000 lint=1.4999999e-08
+ ll=0.00 lw=0.00 lwl=0.00
+ wint=5.0000000e-09 wl=0.00 ww=0.00
+ wwl=0.00 mobmod=1 binunit=2
+ xl= - 0.02e-6 + dxlp xw=0.0 + dxwp dwg=0.00
+ dwb=0.00 ldif=9.00e-08
+ hdif=hdifp rsh=rshp rd=0
+ rs=0 vth0= - 0.4566670 + dvthp
+ lvth0= - 3.5627020e-09 + dlvthp
+ wvth0=1.4777807e-08 + dwvthp
+ pvth0= - 5.1029080e-15 + dpvthp k1=0.4715038
+ lk1=1.0169572e-07 wk1=6.0798340e-08 pk1=-6.3524100e-14
+ k2=5.9786750e-02 + dk2p lk2= - 3.4371000e-08 + dlk2p
+ wk2=-2.4868919e-08 pk2=2.2224691e-14 k3=0.00
+ dvt0=0.00 dvt1=0.00 dvt2=0.00
+ dvt0w=0.00 dvt1w=0.00 dvt2w=0.00
+ nlx=0.00 w0=0.00 k3b=0.00
+ vsat=1.4642856e05 + dvsatp wvsat=0 + dwvsatp
+ lvsat=-7.3928550e-03 ua=1.0361150e-09 lua=-4.7545010e-16
+ wua=-1.6259810e-16 pua=2.5287059e-22 ub=1.0523674e-18
+ lub=1.3379980e-25 wub=-4.9722730e-25 pub=-5.8651310e-32
+ uc=-7.2051170e-11 luc=1.4468274e-17 wuc=-6.6322470e-17
+ puc=-1.2704817e-23 rdsw=5.3000000e02 prwb=0.00
+ prwg=0.00 wr=1.0000000 u0=1.0727104e-02 + du0p
+ lu0= - 1.5289595e-09 + dlu0p
+ wu0= - 1.1454039e-09 + dwu0p pu0=7.8789280e-16 + dpu0p
+ a0=1.1936638 la0=-1.3680231e-07 wa0=-1.2599192e-07
+ pa0=1.8891395e-13 keta=3.5842650e-02 lketa=-9.8931220e-09
+ wketa=-5.8239420e-09 pketa=4.0247990e-15 a1=0.00
+ a2=0.4000000 ags=2.0000000e-02 b0=0.00
+ b1=0.00 voff= - 0.1409845 + dvoffp
+ lvoff=5.2372110e-09 + dlvoffp
+ wvoff=8.2420830e-09 + dwvoffp
+ pvoff= - 3.8668790e-15 + dpvoffp
+ nfactor=1.0000000 + dnfactorp pnfactor=0 + dpnfactorp
+ wnfactor=0 + dwnfactorp lnfactor=0 + dlnfactorp cit=-3.1597191e-04
+ lcit=2.4836766e-10 wcit=9.4362210e-12 pcit=-1.0851648e-17
+ cdsc=0.00 cdscb=0.00 cdscd=0.00
+ eta0=1.7857154e-05 + deta0p peta0=0 + dpeta0p
+ weta0=0 + dweta0p leta0=3.6964260e-11 + dleta0p
+ etab=-1.7857154e-05 letab=-3.6964260e-11 dsub=0.00
+ pclm=0.6714286 lpclm=1.4785714e-07 pdiblc1=1.0000000e-06
+ pdiblc2=1.7857137e-03 lpdiblc2=3.6964290e-09 pdiblcb=1.0000000e-02
+ drout=0.00 pscbe1=3.4999990e08 pscbe2=5.0000000e-07
+ pvag=0.00 delta=1.0000000e-02 alpha0=0.00
+ alpha1=6.8730453846 beta0=22.67827 kt1=-0.2439705
+ lkt1=6.1872760e-09 wkt1=1.3905176e-08 pkt1=-6.0519150e-15
+ kt2=-2.5852976e-02 lkt2=2.5314804e-09 wkt2=5.9186180e-10
+ pkt2=-1.4802061e-15 at=1.0000000e04 ute=-0.7903757
+ lute=1.0183292e-07 wute=7.8833130e-08 pute=-5.9286950e-14
+ ua1=1.2240000e-09 ub1=-1.2162624e-18 lub1=-1.1334610e-25
+ wub1=-7.4653720e-26 pub1=4.9724100e-32 uc1=4.2107970e-11
+ luc1=-2.2106738e-17 wuc1=1.5870021e-17 puc1=1.7282469e-23
+ kt1l=0.00 prt=0 cj=cjp
+ pb=0.895226 mj=0.4476 cjsw=cjswp
+ pbsw=0.895226 mjsw=0.3683619 cjswg=cjswgp
+ pbswg=0.895226 mjswg=0.3683619 cgdo=cgop
+ cgso=cgop tcj=0.0009739001 tcjsw=0.0004130718
+ tcjswg=0.0004130718 tpb=0.001572025 tpbsw=0.001572025
+ tpbswg=0.001572025 js=2.50e-07 jsw=1.2e-12
+ n=1 xti=3 capmod=3
+ nqsmod=0 xpart=1 cf=0
+ tlev=1 tlevc=1
+ dlc=2e-9 llc=-0.039
+ noimod=2 ef=1.064 noia=9.5e+18
+ noib=1.0e5 noic=1.4e-12 em=3.0e+07
+ minr=1e-60 imax=0.01 imelt=0.01

 12: type=p
+ lmin=1.8e-007 lmax=5.000e-07 - dxlp wmin=5.0000e-07 - dxwp
+ wmax=1.2000e-06 - dxwp tnom=25.0 version=3.24
+ tox=toxp toxm=4.08e-09 xj=1.7000001e-07
+ nch=3.9000000e17 lln=-1 lwn=1.0000000
+ wln=1.0000000 wwn=1.0000000 lint=1.4999999e-08
+ ll=0.00 lw=0.00 lwl=0.00
+ wint=5.0000000e-09 wl=0.00 ww=0.00
+ wwl=0.00 mobmod=1 binunit=2
+ xl= - 0.02e-6 + dxlp xw=0.0 + dxwp dwg=0.00
+ dwb=0.00 ldif=9.00e-08
+ hdif=hdifp rsh=rshp rd=0
+ rs=0 vth0= - 0.4463558 + dvthp
+ lvth0= - 8.2027190e-09 + dlvthp
+ wvth0=5.7385650e-09 + dwvthp
+ pvth0= - 1.0352502e-15 + dpvthp k1=0.7171482
+ lk1=-8.8442780e-09 wk1=-1.1417325e-07 pk1=1.5213101e-14
+ k2= - 2.7492139e-02 + dk2p lk2=4.9044990e-09 + dlk2p
+ wk2=3.8377030e-08 pk2=-6.2359860e-15 k3=0.00
+ dvt0=0.00 dvt1=0.00 dvt2=0.00
+ dvt0w=0.00 dvt1w=0.00 dvt2w=0.00
+ nlx=0.00 w0=0.00 k3b=0.00
+ vsat=1.3081246e05 + dvsatp wvsat=0 + dwvsatp
+ lvsat=-3.6561420e-04 ua=-7.3364270e-11 lua=2.3815556e-17
+ wua=5.7265230e-16 pua=-7.7992140e-23 ub=1.4258127e-18
+ lub=-3.4250630e-26 wub=-7.8456510e-25 pub=7.0650720e-32
+ uc=-5.9462960e-11 luc=8.8035780e-18 wuc=-1.0188386e-16
+ puc=3.2978070e-24 rdsw=5.3000000e02 prwb=0.00
+ prwg=0.00 wr=1.0000000 u0=6.8583350e-03 + du0p
+ lu0=2.1198607e-10 + dlu0p wu0=9.2295840e-10 + dwu0p
+ pu0= - 1.4287007e-16 + dpu0p a0=0.5166956
+ la0=1.6783336e-07 wa0=4.8218620e-07 pa0=-8.4766190e-14
+ keta=1.7911140e-02 lketa=-1.8239428e-09 wketa=5.2554230e-09
+ pketa=-9.6091580e-16 a1=0.00 a2=0.4000000
+ ags=1.0547621e-02 lags=4.2535690e-09 wags=1.2594167e-08
+ pags=-5.6673740e-15 b0=0.00 b1=0.00
+ voff= - 0.1286711 + dvoffp
+ lvoff= - 3.0382863e-10 + dlvoffp
+ wvoff=2.8364715e-09 + dwvoffp
+ pvoff= - 1.4343533e-15 + dpvoffp
+ nfactor=1.0000000 + dnfactorp pnfactor=0 + dpnfactorp
+ wnfactor=0 + dwnfactorp lnfactor=0 + dlnfactorp cit=1.2746976e-04
+ lcit=4.8818930e-11 wcit=-2.0641719e-11 pcit=2.6834248e-18
+ cdsc=0.00 cdscb=0.00 cdscd=-5.2000010e-05
+ lcdscd=2.3400004e-11 wcdscd=-2.0304376e-11 pcdscd=9.1369700e-18
+ eta0= - 4.6875000e-04 + deta0p peta0=0 + dpeta0p
+ weta0=0 + dweta0p leta0=2.5593747e-10 + dleta0p
+ etab=6.7187530e-04 letab=-3.4734380e-10 dsub=0.00
+ pclm=0.8585470 lpclm=6.3653840e-08 wpclm=5.6712850e-08
+ ppclm=-2.5520774e-14 pdiblc1=1.0000000e-06 pdiblc2=9.1502970e-03
+ lpdiblc2=3.8236610e-10 wpdiblc2=-1.5742713e-09 ppdiblc2=7.0842200e-16
+ pdiblcb=1.0000000e-02 drout=0.00 pscbe1=3.5000000e08
+ pscbe2=5.0000000e-07 pvag=0.00 delta=1.0000000e-02
+ alpha0=0.00 alpha1=6.8730453846 beta0=22.67827
+ kt1=-0.2211471 lkt1=-4.0832670e-09 wkt1=2.7434011e-10
+ pkt1=8.1960910e-17 kt2=-1.4824204e-02 lkt2=-2.4314675e-09
+ wkt2=-6.1135670e-09 pkt2=1.5372367e-15 at=1.0000000e04
+ ute=-0.5812994 lute=7.7485560e-09 wute=-5.5840220e-08
+ pute=1.3160581e-15 ua1=1.2240000e-09 ub1=-1.6175756e-18
+ lub1=6.7244840e-26 wub1=8.3021400e-26 pub1=-2.1229706e-32
+ uc1=-2.2818641e-11 luc1=7.1102340e-18 wuc1=7.5301860e-17
+ puc1=-9.4618550e-24 kt1l=0.00 prt=0
+ cj=cjp pb=0.895226 mj=0.4476
+ cjsw=cjswp pbsw=0.895226 mjsw=0.3683619
+ cjswg=cjswgp pbswg=0.895226 mjswg=0.3683619
+ cgdo=cgop cgso=cgop tcj=0.0009739001
+ tcjsw=0.0004130718 tcjswg=0.0004130718 tpb=0.001572025
+ tpbsw=0.001572025 tpbswg=0.001572025 js=2.50e-07
+ jsw=1.2e-12 n=1 xti=3
+ capmod=3 nqsmod=0 xpart=1
+ cf=0 tlev=1 tlevc=1
+ dlc=2e-9
+ llc=-0.039 noimod=2 ef=1.064
+ noia=9.5e+18 noib=1.0e5 noic=1.4e-12
+ em=3.0e+07
+ minr=1e-60 imax=0.01 imelt=0.01

 13: type=p
+ lmin=1.000e-05 - dxlp lmax=20.001e-006 wmin=2.2e-007
+ wmax=5.0000e-07 - dxwp tnom=25.0 version=3.24
+ tox=toxp toxm=4.08e-09 xj=1.7000001e-07
+ nch=3.9000000e17 lln=-1 lwn=1.0000000
+ wln=1.0000000 wwn=1.0000000 lint=1.4999999e-08
+ ll=0.00 lw=0.00 lwl=0.00
+ wint=5.0000000e-09 wl=0.00 ww=0.00
+ wwl=0.00 mobmod=1 binunit=2
+ xl= - 0.02e-6 + dxlp xw=0.0 + dxwp dwg=0.00
+ dwb=0.00 ldif=9.00e-08
+ hdif=hdifp rsh=rshp rd=0
+ rs=0 vth0= - 0.4484667 + dvthp
+ pvth0=0 + dpvthp wvth0=9.3406130e-09 + dwvthp
+ k1=0.5421249 lvth0=0 + dlvthp wk1=3.5615110e-09
+ k2=3.5676420e-02 + dk2p lk2=0 + dlk2p wk2=-4.7198290e-09
+ k3=0.00 dvt0=0.00 dvt1=0.00
+ dvt2=0.00 dvt0w=0.00 dvt1w=0.00
+ dvt2w=0.00 nlx=0.00 w0=0.00
+ k3b=0.00 vsat=1.4999998e05 + dvsatp
+ wvsat=0 + dwvsatp ua=1.2584637e-09 wua=-2.3131395e-16
+ ub=4.9999990e-20 uc=-1.6065008e-10 wuc=-1.2695932e-17
+ rdsw=5.3000000e02 prwb=0.00 prwg=0.00
+ wr=1.0000000 u0=9.7483340e-03 + du0p pu0=0 + dpu0p
+ lu0=0 + dlu0p wu0= - 4.0346860e-11 + dwu0p
+ a0=0.8704194 wa0=8.9511660e-08 keta=4.3109410e-02
+ wketa=-6.4034920e-09 a1=0.00 a2=0.4000000
+ ags=2.0000000e-02 b0=0.00 b1=0.00
+ voff= - 0.1261533 + dvoffp pvoff=0 + dpvoffp
+ lvoff=0 + dlvoffp wvoff= - 1.3202980e-09 + dwvoffp
+ nfactor=1.0000000 + dnfactorp pnfactor=0 + dpnfactorp
+ wnfactor=0 + dwnfactorp lnfactor=0 + dlnfactorp cit=-1.0000000e-04
+ cdsc=0.00 cdscb=0.00 cdscd=0.00
+ eta0=5.0000000e-05 + deta0p peta0=0 + dpeta0p
+ weta0=0 + dweta0p leta0=0 + dleta0p etab=-5.0000000e-05
+ dsub=0.00 pclm=0.5999999 pdiblc1=1.0000000e-06
+ pdiblc2=1.0000000e-03 pdiblcb=1.0000000e-02 drout=0.00
+ pscbe1=1.9999997e08 pscbe2=5.0000000e-07 pvag=0.00
+ delta=1.0000000e-02 alpha0=0.00 alpha1=6.8730453846
+ beta0=22.67827 kt1=-0.2247607 wkt1=3.8305540e-09
+ kt2=-2.7069092e-02 wkt2=1.9527771e-09 at=1.0000000e04
+ ute=-0.7678431 wute=6.8981090e-09 ua1=1.2240000e-09
+ ub1=-1.3041941e-18 wub1=2.1644123e-27 uc1=6.6651710e-11
+ wuc1=-1.2526765e-17 kt1l=0.00 prt=0
+ cj=cjp pb=0.895226 mj=0.4476
+ cjsw=cjswp pbsw=0.895226 mjsw=0.3683619
+ cjswg=cjswgp pbswg=0.895226 mjswg=0.3683619
+ cgdo=cgop cgso=cgop tcj=0.0009739001
+ tcjsw=0.0004130718 tcjswg=0.0004130718 tpb=0.001572025
+ tpbsw=0.001572025 tpbswg=0.001572025 js=2.50e-07
+ jsw=1.2e-12 n=1 xti=3
+ capmod=3 nqsmod=0 xpart=1
+ cf=0 tlev=1 tlevc=1
+ dlc=2e-9
+ llc=-0.039 noimod=2 ef=1.064
+ noia=9.5e+18 noib=1.0e5 noic=1.4e-12
+ em=3.0e+07
+ minr=1e-60 imax=0.01 imelt=0.01

 14: type=p
+ lmin=1.200e-06 - dxlp lmax=1.000e-05 - dxlp wmin=2.2e-007
+ wmax=5.0000e-07 - dxwp tnom=25.0 version=3.24
+ tox=toxp toxm=4.08e-09 xj=1.7000001e-07
+ nch=3.9000000e17 lln=-1 lwn=1.0000000
+ wln=1.0000000 wwn=1.0000000 lint=1.4999999e-08
+ ll=0.00 lw=0.00 lwl=0.00
+ wint=5.0000000e-09 wl=0.00 ww=0.00
+ wwl=0.00 mobmod=1 binunit=2
+ xl= - 0.02e-6 + dxlp xw=0.0 + dxwp dwg=0.00
+ dwb=0.00 ldif=9.00e-08
+ hdif=hdifp rsh=rshp rd=0
+ rs=0 vth0= - 0.4480035 + dvthp
+ lvth0= - 4.6083350e-09 + dlvthp
+ wvth0=9.7064800e-09 + dwvthp
+ pvth0= - 3.6403820e-15 + dpvthp k1=0.5470301
+ lk1=-4.8806700e-08 wk1=-2.4364055e-10 pk1=3.7861260e-14
+ k2=3.3334490e-02 + dk2p lk2=2.3302198e-08 + dlk2p
+ wk2=-3.0947396e-09 pk2=-1.6169635e-14 k3=0.00
+ dvt0=0.00 dvt1=0.00 dvt2=0.00
+ dvt0w=0.00 dvt1w=0.00 dvt2w=0.00
+ nlx=0.00 w0=0.00 k3b=0.00
+ vsat=1.5130680e05 + dvsatp wvsat=0 + dwvsatp
+ lvsat=-1.3002842e-02 ua=1.2617201e-09 lua=-3.2401100e-17
+ wua=-2.2991296e-16 pua=-1.3939852e-23 ub=5.0039600e-20
+ lub=-3.9414270e-28 wub=-1.1822094e-29 pub=1.1764949e-34
+ uc=-1.5373321e-10 luc=-6.8822930e-17 wuc=-1.4112429e-17
+ puc=1.4094153e-23 rdsw=5.3000000e02 prwb=0.00
+ prwg=0.00 wr=1.0000000 u0=9.7784860e-03 + du0p
+ lu0= - 3.0000519e-10 + dlu0p wu0=2.2217313e-11 + dwu0p
+ pu0= - 6.2251350e-16 + dpu0p a0=0.8193527
+ la0=5.0811370e-07 wa0=1.0814799e-07 pa0=-1.8543150e-13
+ keta=4.7694810e-02 lketa=-4.5624760e-08 wketa=-8.1672530e-09
+ pketa=1.7549415e-14 a1=0.00 a2=0.4000000
+ ags=2.0000000e-02 b0=0.00 b1=0.00
+ voff= - 0.1259132 + dvoffp
+ lvoff= - 2.3886029e-09 + dlvoffp
+ wvoff= - 1.5900530e-09 + dwvoffp
+ pvoff=2.6840621e-15 + dpvoffp
+ nfactor=1.0000000 + dnfactorp pnfactor=0 + dpnfactorp
+ wnfactor=0 + dwnfactorp lnfactor=0 + dlnfactorp cit=-1.0000000e-04
+ cdsc=0.00 cdscb=0.00 cdscd=0.00
+ eta0=5.0000000e-05 + deta0p peta0=0 + dpeta0p
+ weta0=0 + dweta0p leta0=0 + dleta0p etab=-5.0000000e-05
+ dsub=0.00 pclm=0.5738635 lpclm=2.6005691e-07
+ pdiblc1=1.0000000e-06 pdiblc2=4.7727290e-04 lpdiblc2=5.2011360e-09
+ pdiblcb=1.0000000e-02 drout=0.00 pscbe1=1.8039770e08
+ lpscbe1=1.9504262e02 pscbe2=5.0000000e-07 pvag=0.00
+ delta=1.0000000e-02 alpha0=0.00 alpha1=6.8730453846
+ beta0=22.67827 kt1=-0.2237138 lkt1=-1.0417262e-08
+ wkt1=3.5742560e-09 pkt1=2.5501714e-15 kt2=-2.6908273e-02
+ lkt2=-1.6001408e-09 wkt2=2.0011981e-09 pkt2=-4.8178840e-16
+ at=1.0000000e04 ute=-0.7908860 lute=2.2927659e-07
+ wute=1.1298283e-08 pute=-4.3781730e-14 ua1=1.2240000e-09
+ ub1=-1.2832692e-18 lub1=-2.0820251e-25 wub1=-3.0198158e-27
+ pub1=5.1583110e-32 uc1=5.6680550e-11 luc1=9.9213070e-17
+ wuc1=-1.0513175e-17 puc1=-2.0035212e-23 kt1l=0.00
+ prt=0 cj=cjp pb=0.895226
+ mj=0.4476 cjsw=cjswp pbsw=0.895226
+ mjsw=0.3683619 cjswg=cjswgp pbswg=0.895226
+ mjswg=0.3683619 cgdo=cgop cgso=cgop
+ tcj=0.0009739001 tcjsw=0.0004130718 tcjswg=0.0004130718
+ tpb=0.001572025 tpbsw=0.001572025 tpbswg=0.001572025
+ js=2.50e-07 jsw=1.2e-12 n=1
+ xti=3 capmod=3 nqsmod=0
+ xpart=1 cf=0 tlev=1
+ tlevc=1
+ dlc=2e-9 llc=-0.039 noimod=2
+ ef=1.064 noia=9.5e+18 noib=1.0e5
+ noic=1.4e-12 em=3.0e+07
+ minr=1e-60 imax=0.01 imelt=0.01

 15: type=p
+ lmin=5.000e-07 - dxlp lmax=1.200e-06 - dxlp wmin=2.2e-007
+ wmax=5.0000e-07 - dxwp tnom=25.0 version=3.24
+ tox=toxp toxm=4.08e-09 xj=1.7000001e-07
+ nch=3.9000000e17 lln=-1 lwn=1.0000000
+ wln=1.0000000 wwn=1.0000000 lint=1.4999999e-08
+ ll=0.00 lw=0.00 lwl=0.00
+ wint=5.0000000e-09 wl=0.00 ww=0.00
+ wwl=0.00 mobmod=1 binunit=2
+ xl= - 0.02e-6 + dxlp xw=0.0 + dxwp dwg=0.00
+ dwb=0.00 ldif=9.00e-08
+ hdif=hdifp rsh=rshp rd=0
+ rs=0 vth0= - 0.4385042 + dvthp
+ lvth0= - 1.5532533e-08 + dlvthp
+ wvth0=5.8780540e-09 + dwvthp
+ pvth0=7.6230860e-16 + dpvthp k1=0.5102190
+ lk1=-6.4738780e-09 wk1=4.1827890e-08 pk1=-1.0521005e-14
+ k2=5.4106280e-02 + dk2p lk2= - 5.8536280e-10 + dlk2p
+ wk2=-2.2085489e-08 pk2=5.6697290e-15 k3=0.00
+ dvt0=0.00 dvt1=0.00 dvt2=0.00
+ dvt0w=0.00 dvt1w=0.00 dvt2w=0.00
+ nlx=0.00 w0=0.00 k3b=0.00
+ vsat=1.4642852e05 + dvsatp wvsat=0 + dwvsatp
+ lvsat=-7.3928160e-03 ua=1.0922192e-09 lua=1.6252487e-16
+ wua=-1.9008923e-16 pua=-5.9737160e-23 ub=2.0536515e-20
+ lub=3.3534410e-26 wub=8.3698470e-27 pub=-9.5212690e-33
+ uc=-2.1836380e-10 luc=5.5022750e-18 wuc=5.3707260e-18
+ puc=-8.3114780e-24 rdsw=5.3000000e02 prwb=0.00
+ prwg=0.00 wr=1.0000000 u0=9.2032870e-03 + du0p
+ lu0=3.6147370e-10 + dlu0p
+ wu0= - 3.9873410e-10 + dwu0p
+ pu0= - 1.3841940e-16 + dpu0p a0=1.1508681
+ la0=1.2687106e-07 wa0=-1.0502199e-07 pa0=5.9713990e-14
+ keta=4.4842080e-04 lketa=8.7085910e-09 wketa=1.1519229e-08
+ pketa=-5.0900410e-15 a1=0.00 a2=0.4000000
+ ags=2.0000000e-02 b0=0.00 b1=0.00
+ voff= - 0.1186655 + dvoffp
+ lvoff= - 1.0723419e-08 + dlvoffp
+ wvoff= - 2.6941984e-09 + dwvoffp
+ pvoff=3.9538300e-15 + dpvoffp
+ nfactor=1.0000000 + dnfactorp pnfactor=0 + dpnfactorp
+ wnfactor=0 + dwnfactorp lnfactor=0 + dlnfactorp cit=-2.9671428e-04
+ lcit=2.2622144e-10 cdsc=0.00 cdscb=0.00
+ cdscd=0.00 eta0=1.7857146e-05 + deta0p
+ peta0=0 + dpeta0p weta0=0 + dweta0p
+ leta0=3.6964280e-11 + dleta0p etab=-1.7857146e-05
+ letab=-3.6964280e-11 dsub=0.00 pclm=0.6714286
+ lpclm=1.4785714e-07 pdiblc1=1.0000000e-06 pdiblc2=1.7857139e-03
+ lpdiblc2=3.6964290e-09 pdiblcb=1.0000000e-02 drout=0.00
+ pscbe1=3.4999990e08 pscbe2=5.0000000e-07 pvag=0.00
+ delta=1.0000000e-02 alpha0=0.00 alpha1=6.8730453846
+ beta0=22.67827 kt1=-0.2426738 lkt1=1.1386779e-08
+ wkt1=1.3269771e-08 pkt1=-8.5996710e-15 kt2=-2.7530843e-02
+ lkt2=-8.8418580e-10 wkt2=1.4140165e-09 pkt2=1.9347028e-16
+ at=1.0000000e04 ute=-0.5904401 lute=-1.2362289e-09
+ wute=-1.9135335e-08 pute=-8.7830670e-15 ua1=1.2240000e-09
+ ub1=-1.4562286e-18 lub1=-9.2991590e-27 wub1=4.2929760e-26
+ pub1=-1.2589071e-33 uc1=1.3909653e-10 luc1=4.4346890e-18
+ wuc1=-3.1654370e-17 puc1=4.2771700e-24 kt1l=0.00
+ prt=0 cj=cjp pb=0.895226
+ mj=0.4476 cjsw=cjswp pbsw=0.895226
+ mjsw=0.3683619 cjswg=cjswgp pbswg=0.895226
+ mjswg=0.3683619 cgdo=cgop cgso=cgop
+ tcj=0.0009739001 tcjsw=0.0004130718 tcjswg=0.0004130718
+ tpb=0.001572025 tpbsw=0.001572025 tpbswg=0.001572025
+ js=2.50e-07 jsw=1.2e-12 n=1
+ xti=3 capmod=3 nqsmod=0
+ xpart=1 cf=0 tlev=1
+ tlevc=1
+ dlc=2e-9 llc=-0.039 noimod=2
+ ef=1.064 noia=9.5e+18 noib=1.0e5
+ noic=1.4e-12 em=3.0e+07
+ minr=1e-60 imax=0.01 imelt=0.01

 16: type=p
+ lmin=1.8e-007 lmax=5.000e-07 - dxlp wmin=2.2e-007
+ wmax=5.0000e-07 - dxwp tnom=25.0 version=3.24
+ tox=toxp toxm=4.08e-09 xj=1.7000001e-07
+ nch=3.9000000e17 lln=-1 lwn=1.0000000
+ wln=1.0000000 wwn=1.0000000 lint=1.4999999e-08
+ ll=0.00 lw=0.00 lwl=0.00
+ wint=5.0000000e-09 wl=0.00 ww=0.00
+ wwl=0.00 mobmod=1 binunit=2
+ xl= - 0.02e-6 + dxlp xw=0.0 + dxwp dwg=0.00
+ dwb=0.00 ldif=9.00e-08
+ hdif=hdifp rsh=rshp rd=0
+ rs=0 vth0= - 0.4513863 + dvthp
+ lvth0= - 9.7355810e-09 + dlvthp
+ wvth0=8.2035130e-09 + dwvthp
+ pvth0= - 2.8414808e-16 + dpvthp k1=0.4651900
+ lk1=1.3789155e-08 wk1=9.2862840e-09 pk1=4.1227180e-15
+ k2=5.9709800e-02 + dk2p lk2= - 3.1069460e-09 + dlk2p
+ wk2=-4.3519210e-09 pk2=-2.3103772e-15 k3=0.00
+ dvt0=0.00 dvt1=0.00 dvt2=0.00
+ dvt0w=0.00 dvt1w=0.00 dvt2w=0.00
+ nlx=0.00 w0=0.00 k3b=0.00
+ vsat=1.3081255e05 + dvsatp wvsat=0 + dwvsatp
+ lvsat=-3.6563360e-04 ua=2.0400983e-09 lua=-2.6402067e-16
+ wua=-4.6294430e-16 pua=6.3047610e-23 ub=-4.9040330e-19
+ lub=2.6345733e-25 wub=1.5438073e-25 pub=-7.5226180e-32
+ uc=-2.8037866e-10 luc=3.3408970e-17 wuc=6.3648470e-18
+ puc=-8.7588340e-24 rdsw=5.3000000e02 prwb=0.00
+ prwg=0.00 wr=1.0000000 u0=1.0799064e-02 + du0p
+ lu0= - 3.5662620e-10 + dlu0p
+ wu0= - 1.0079994e-09 + dwu0p pu0=1.3574996e-16 + dpu0p
+ a0=1.4167303 la0=7.2330520e-09 wa0=4.1169190e-08
+ pa0=-6.0720430e-15 keta=3.1593680e-02 lketa=-5.3067750e-09
+ wketa=-1.4490222e-09 pketa=7.4567200e-16 a1=0.00
+ a2=0.4000000 ags=3.6250000e-02 lags=-7.3124990e-09
+ b0=0.00 b1=0.00
+ voff= - 0.1287204 + dvoffp
+ lvoff= - 6.1987190e-09 + dlvoffp
+ wvoff=2.8606606e-09 + dwvoffp
+ pvoff=1.4541431e-15 + dpvoffp
+ nfactor=1.0000000 + dnfactorp pnfactor=0 + dpnfactorp
+ wnfactor=0 + dwnfactorp lnfactor=0 + dlnfactorp cit=8.5343770e-05
+ lcit=5.4295310e-11 cdsc=0.00 cdscb=0.00
+ cdscd=-6.4492230e-05 lcdscd=2.9021494e-11 wcdscd=-1.4183201e-11
+ pcdscd=6.3824410e-18 eta0= - 4.6875020e-04 + deta0p
+ peta0=0 + dpeta0p weta0=0 + dweta0p
+ leta0=2.5593758e-10 + dleta0p etab=6.7187530e-04
+ letab=-3.4734380e-10 dsub=0.00 pclm=0.9648299
+ lpclm=1.5826547e-08 wpclm=4.6342220e-09 ppclm=-2.0853998e-15
+ pdiblc1=1.0000000e-06 pdiblc2=5.9374990e-03 lpdiblc2=1.8281252e-09
+ pdiblcb=1.0000000e-02 drout=0.00 pscbe1=3.5000000e08
+ pscbe2=5.0000000e-07 pvag=0.00 delta=1.0000000e-02
+ alpha0=0.00 alpha1=6.8730453846 beta0=22.67827
+ kt1=-0.2130934 lkt1=-1.9244071e-09 wkt1=-3.6719870e-09
+ pkt1=-9.7588050e-16 kt2=-3.5890840e-02 lkt2=2.8778120e-09
+ wkt2=4.2090850e-09 pkt2=-1.0643102e-15 at=1.0000000e04
+ ute=-0.5893072 lute=-1.7460413e-09 wute=-5.1916390e-08
+ pute=5.9684110e-15 ua1=1.2240000e-09 ub1=-1.4433942e-18
+ lub1=-1.5074642e-26 wub1=-2.3274574e-27 pub1=1.9106841e-32
+ uc1=2.0396977e-10 luc1=-2.4758267e-17 wuc1=-3.5824470e-17
+ puc1=6.1537120e-24 kt1l=0.00 prt=0
+ cj=cjp pb=0.895226 mj=0.4476
+ cjsw=cjswp pbsw=0.895226 mjsw=0.3683619
+ cjswg=cjswgp pbswg=0.895226 mjswg=0.3683619
+ cgdo=cgop cgso=cgop tcj=0.0009739001
+ tcjsw=0.0004130718 tcjswg=0.0004130718 tpb=0.001572025
+ tpbsw=0.001572025 tpbswg=0.001572025 js=2.50e-07
+ jsw=1.2e-12 n=1 xti=3
+ capmod=3 nqsmod=0 xpart=1
+ cf=0 tlev=1 tlevc=1
+ dlc=2e-9
+ llc=-0.039 noimod=2 ef=1.064
+ noia=9.5e+18 noib=1.0e5 noic=1.4e-12
+ em=3.0e+07
+ minr=1e-60 imax=0.01 imelt=0.01

     }

subckt nch_mis ( d g s b )
parameters l=18.e-08 w=1.5e-6 multi=1 ad=2*hdifn*w as=2*hdifn*w pd=2*(2*hdifn+w) ps=2*(2*hdifn+w) nrd=hdifn/w nrs=hdifn/w
+ lef=l - 20e-9 wef=w geo_fac=1 / sqrt(multi
+ * lef * wef * 1e12) vthmis=3.635e-3 * geo_fac * vthnmis dlmis=4.58e-3 * geo_fac
+ * lef * dlnmis dwmis=3.73e-3 * geo_fac * wef * dwnmis toxmis=1.01e-3 * geo_fac
+ * toxn * toxnmis

//  ****************************
m0 ( d g s b ) nchmis w=w l=l ad=ad as=as pd=pd ps=ps nrd=nrd nrs=nrs m=multi

model nchmis bsim3v3  {
     1: type=n
+ lmin=1.000e-05-dxln-dlmis lmax=20.001e-006          wmin=1.0000e-05-dxwn-dwmis
+ wmax=900.001e-6           tnom=25.0                 version=3.24
+ tox=toxn+toxmis           toxm=4.08e-09             xj=1.6000000e-07
+ nch=3.9000000e17          lln=-1                    lwn=1.0000000
+ wln=1.0000000             wwn=1                     lint=1.0000000e-08
+ ll=0.00                   lw=0.00                   lwl=0.00
+ wint=3.0000000e-09        wl=0.00                   ww=0.00
+ wwl=0.00                  mobmod=1                  binunit=2
+ xl=-0.02e-6+dxln+dlmis    xw=0.0+dxwn+dwmis         dwg=0.00
+ dwb=0.00                  ldif=9.00e-08             hdif=hdifn
+ rsh=rshn                  rd=0                      rs=0
+ vth0=0.4365561+dvthn+vthmis                         wvth0=0+dwvthn
+ pvth0=0+dpvthn            lvth0=0+dlvthn            k1=dk1n+0.5142301
+ k2=1.4797844e-02+dk2n     lk2=0+dlk2n               k3=0.00
+ dvt0=0.00                 dvt1=0.00                 dvt2=0.00
+ dvt0w=0.00                dvt1w=0.00                dvt2w=0.00
+ nlx=0.00                  w0=0.00                   k3b=0.00
+ vsat=9.0000010e04+dvsatn  wvsat=0+dwvsatn           ua=-6.1227400e-10
+ ub=2.3135539e-18          uc=1.0876087e-10          rdsw=drdswn+1.7000000e02
+ prwb=0.00                 prwg=0.00                 wr=1.0000000
+ u0=du0n+4.2203390e-02     a0=0.3700794              pu0=0+dpu0n
+ wu0=0+dwu0n               lu0=0+dlu0n               keta=9.2634850e-03
+ a1=0.00                   a2=0.9900000              ags=2.0000000e-02
+ b0=0.00                   b1=0.00                   voff=-0.1405780+dvoffn
+ pvoff=0+dpvoffn           wvoff=0+dwvoffn           lvoff=0+dlvoffn
+ nfactor=1.0000000+dnfactorn                         pnfactor=0+dpnfactorn
+ wnfactor=0+dwnfactorn     lnfactor=0+dlnfactorn     cit=-1.0000001e-04
+ cdsc=0.00                 cdscb=0.00                cdscd=0.00
+ eta0=5.0000000e-05+deta0n peta0=0+dpeta0n           weta0=0+dweta0n
+ leta0=0+dleta0n           etab=-5.0000000e-05       dsub=0.00
+ pclm=0.8000001            pdiblc1=1.0000000e-06     pdiblc2=6.9999990e-04
+ pdiblcb=1.0000000e-02     drout=0.00                pscbe1=2.0000003e08
+ pscbe2=1.0000000e-06      pvag=0.00                 delta=1.0000000e-02
+ alpha0=0.0                alpha1=0.448150714        beta0=11.59263
+ kt1=-0.2240464            kt2=-3.0266136e-02        at=2.0000000e04
+ ute=-1.5799998            ua1=1.2240000e-09         ub1=-1.1209314e-18
+ uc1=1.1643822e-11         kt1l=0.00                 prt=0
+ cj=cjn                    pb=0.6882682              mj=0.3595262
+ cjsw=cjswn                pbsw=0.6882682            mjsw=0.2003879
+ cjswg=cjswgn              pbswg=0.6882682           mjswg=0.43879
+ cgdo=cgon                 cgso=cgon                 tcj=0.001040287
+ tcjsw=0.000645489         tcjswg=0.000645489        tpb=0.001554306
+ tpbsw=0.001554306         tpbswg=0.001554306        js=3.50e-07
+ jsw=1.45e-12              n=1                       xti=3
+ capmod=3                  nqsmod=0                  xpart=1
+ cf=0                      tlev=1                    tlevc=1
+ dlc=3e-9                  llc=-0.039                noimod=2
+ ef=0.874                  noia=2.0e+19              noib=1.2e4
+ noic=2.5e-13              em=3.0e+07                minr=1e-60
+ imax=0.01                 imelt=0.01

     2: type=n
+ lmin=1.200e-06-dxln-dlmis lmax=1.000e-05-dxln-dlmis wmin=1.0000e-05-dxwn-dwmis
+ wmax=900.001e-6           tnom=25.0                 version=3.24
+ tox=toxn+toxmis           toxm=4.08e-09             xj=1.6000000e-07
+ nch=3.9000000e17          lln=-1                    lwn=1.0000000
+ wln=1.0000000             wwn=1                     lint=1.0000000e-08
+ ll=0.00                   lw=0.00                   lwl=0.00
+ wint=3.0000000e-09        wl=0.00                   ww=0.00
+ wwl=0.00                  mobmod=1                  binunit=2
+ xl=-0.02e-6+dxln+dlmis    xw=0.0+dxwn+dwmis         dwg=0.00
+ dwb=0.00                  ldif=9.00e-08             hdif=hdifn
+ rsh=rshn                  rd=0                      rs=0
+ vth0=0.4304705+dvthn+vthmis                         lvth0=6.0612870e-08+dlvthn
+ wvth0=0+dwvthn            pvth0=0+dpvthn            k1=dk1n+0.5127332
+ lk1=1.4908844e-08         k2=1.5913647e-02+dk2n     lk2=-1.1113380e-08+dlk2n
+ k3=0.00                   dvt0=0.00                 dvt1=0.00
+ dvt2=0.00                 dvt0w=0.00                dvt1w=0.00
+ dvt2w=0.00                nlx=0.00                  w0=0.00
+ k3b=0.00                  vsat=9.0658910e04+dvsatn  wvsat=0+dwvsatn
+ lvsat=-6.5626380e-03      ua=-5.6565540e-10         lua=-4.6432160e-16
+ ub=2.2395009e-18          lub=7.3756770e-25         uc=1.0484686e-10
+ luc=3.8983550e-17         rdsw=drdswn+1.7000000e02  prwb=0.00
+ prwg=0.00                 wr=1.0000000              u0=du0n+4.1872890e-02
+ pu0=0+dpu0n               wu0=0+dwu0n               lu0=3.2918090e-09+dlu0n
+ a0=0.4051808              la0=-3.4960930e-07        keta=1.3601619e-02
+ lketa=-4.3207810e-08      a1=0.00                   a2=0.9900000
+ ags=2.0000000e-02         b0=0.00                   b1=0.00
+ voff=-0.1395267+dvoffn    pvoff=0+dpvoffn           wvoff=0+dwvoffn
+ lvoff=-1.0471328e-08+dlvoffn                        nfactor=1.0000000+dnfactorn
+ pnfactor=0+dpnfactorn     wnfactor=0+dwnfactorn     lnfactor=0+dlnfactorn
+ cit=-1.2675911e-04        lcit=2.6652053e-10        cdsc=0.00
+ cdscb=0.00                cdscd=0.00                eta0=5.0000000e-05+deta0n
+ peta0=0+dpeta0n           weta0=0+dweta0n           leta0=0+dleta0n
+ etab=-5.0000000e-05       dsub=0.00                 pclm=0.7736172
+ lpclm=2.6277317e-07       pdiblc1=1.0000000e-06     pdiblc2=3.9681810e-04
+ lpdiblc2=3.0196912e-09    pdiblcb=1.0000000e-02     drout=0.00
+ pscbe1=1.7363640e08       lpscbe1=2.6258185e02      pscbe2=1.0000000e-06
+ pvag=0.00                 delta=1.0000000e-02       alpha0=0.0
+ alpha1=0.448150714        beta0=11.59263            kt1=-0.2240468
+ kt2=-3.0265680e-02        lkt2=-4.5534910e-12       at=2.0000000e04
+ ute=-1.5799941            lute=-5.7439530e-11       ua1=1.2240000e-09
+ ub1=-1.1209769e-18        lub1=4.5273170e-28        uc1=1.1635963e-11
+ luc1=7.8277720e-20        kt1l=0.00                 prt=0
+ cj=cjn                    pb=0.6882682              mj=0.3595262
+ cjsw=cjswn                pbsw=0.6882682            mjsw=0.2003879
+ cjswg=cjswgn              pbswg=0.6882682           mjswg=0.43879
+ cgdo=cgon                 cgso=cgon                 tcj=0.001040287
+ tcjsw=0.000645489         tcjswg=0.000645489        tpb=0.001554306
+ tpbsw=0.001554306         tpbswg=0.001554306        js=3.50e-07
+ jsw=1.45e-12              n=1                       xti=3
+ capmod=3                  nqsmod=0                  xpart=1
+ cf=0                      tlev=1                    tlevc=1
+ dlc=3e-9                  llc=-0.039                noimod=2
+ ef=0.874                  noia=2.0e+19              noib=1.2e4
+ noic=2.5e-13              em=3.0e+07                minr=1e-60
+ imax=0.01                 imelt=0.01

     3: type=n
+ lmin=5.000e-07-dxln-dlmis lmax=1.200e-06-dxln-dlmis wmin=1.0000e-05-dxwn-dwmis
+ wmax=900.001e-6           tnom=25.0                 version=3.24
+ tox=toxn+toxmis           toxm=4.08e-09             xj=1.6000000e-07
+ nch=3.9000000e17          lln=-1                    lwn=1.0000000
+ wln=1.0000000             wwn=1                     lint=1.0000000e-08
+ ll=0.00                   lw=0.00                   lwl=0.00
+ wint=3.0000000e-09        wl=0.00                   ww=0.00
+ wwl=0.00                  mobmod=1                  binunit=2
+ xl=-0.02e-6+dxln+dlmis    xw=0.0+dxwn+dwmis         dwg=0.00
+ dwb=0.00                  ldif=9.00e-08             hdif=hdifn
+ rsh=rshn                  rd=0                      rs=0
+ vth0=0.4793240+dvthn+vthmis                         lvth0=3.9427570e-09+dlvthn
+ wvth0=0+dwvthn            pvth0=0+dpvthn            k1=dk1n+0.5318048
+ lk1=-7.2142460e-09        k2=4.8649130e-03+dk2n     lk2=1.7031510e-09+dlk2n
+ k3=0.00                   dvt0=0.00                 dvt1=0.00
+ dvt2=0.00                 dvt0w=0.00                dvt1w=0.00
+ dvt2w=0.00                nlx=0.00                  w0=0.00
+ k3b=0.00                  vsat=8.5658600e04+dvsatn  wvsat=0+dwvsatn
+ lvsat=-7.6228570e-04      ua=-1.0347512e-09         lua=7.9829660e-17
+ ub=3.0100842e-18          lub=-1.5630905e-25        uc=1.4678947e-10
+ luc=-9.6698950e-18        rdsw=drdswn+1.7000000e02  prwb=0.00
+ prwg=0.00                 wr=1.0000000              u0=du0n+4.3813580e-02
+ pu0=0+dpu0n               wu0=0+dwu0n               lu0=1.0406079e-09+dlu0n
+ a0=-0.2911571             la0=4.5814260e-07         keta=-1.5927497e-02
+ lketa=-8.9540290e-09      a1=0.00                   a2=0.9900000
+ ags=4.6247400e-02         lags=-3.0446980e-08       b0=0.00
+ b1=0.00                   voff=-0.1621186+dvoffn    pvoff=0+dpvoffn
+ wvoff=0+dwvoffn           lvoff=1.5735258e-08+dlvoffn
+ nfactor=1.0000000+dnfactorn                         pnfactor=0+dpnfactorn
+ wnfactor=0+dwnfactorn     lnfactor=0+dlnfactorn     cit=-1.5788565e-04
+ lcit=3.0262734e-10        cdsc=0.00                 cdscb=0.00
+ cdscd=0.00                eta0=1.7142866e-05+deta0n peta0=0+dpeta0n
+ weta0=0+dweta0n           leta0=3.8114280e-11+dleta0n
+ etab=-1.7142866e-05       letab=-3.8114280e-11      dsub=0.00
+ pclm=0.8687172            lpclm=1.5245718e-07       pdiblc1=1.0000000e-06
+ pdiblc2=1.6847569e-03     lpdiblc2=1.5256820e-09    pdiblcb=1.0000000e-02
+ drout=0.00                pscbe1=4.0000010e08       pscbe2=1.0000000e-06
+ pvag=0.00                 delta=1.0000000e-02       alpha0=0.0
+ alpha1=0.448150714        beta0=11.59263            kt1=-0.2290285
+ lkt1=5.7826780e-09        kt2=-3.1611919e-02        lkt2=1.5570838e-09
+ at=2.0000000e04           ute=-1.3504703            lute=-2.6630502e-07
+ ua1=1.2266247e-09         lua1=-3.0446746e-18       ub1=-8.5743860e-20
+ lub1=-1.2004175e-24       uc1=6.7886830e-11         luc1=-6.5172730e-17
+ kt1l=0.00                 prt=0                     cj=cjn
+ pb=0.6882682              mj=0.3595262              cjsw=cjswn
+ pbsw=0.6882682            mjsw=0.2003879            cjswg=cjswgn
+ pbswg=0.6882682           mjswg=0.43879             cgdo=cgon
+ cgso=cgon                 tcj=0.001040287           tcjsw=0.000645489
+ tcjswg=0.000645489        tpb=0.001554306           tpbsw=0.001554306
+ tpbswg=0.001554306        js=3.50e-07               jsw=1.45e-12
+ n=1                       xti=3                     capmod=3
+ nqsmod=0                  xpart=1                   cf=0
+ tlev=1                    tlevc=1                   dlc=3e-9
+ llc=-0.039                noimod=2                  ef=0.874
+ noia=2.0e+19              noib=1.2e4                noic=2.5e-13
+ em=3.0e+07                minr=1e-60                imax=0.01
+ imelt=0.01

     4: type=n
+ lmin=1.8e-007             lmax=5.000e-07-dxln-dlmis wmin=1.0000e-05-dxwn-dwmis
+ wmax=900.001e-6           tnom=25.0                 version=3.24
+ tox=toxn+toxmis           toxm=4.08e-09             xj=1.6000000e-07
+ nch=3.9000000e17          lln=-1                    lwn=1.0000000
+ wln=1.0000000             wwn=1                     lint=1.0000000e-08
+ ll=0.00                   lw=0.00                   lwl=0.00
+ wint=3.0000000e-09        wl=0.00                   ww=0.00
+ wwl=0.00                  mobmod=1                  binunit=2
+ xl=-0.02e-6+dxln+dlmis    xw=0.0+dxwn+dwmis         dwg=0.00
+ dwb=0.00                  ldif=9.00e-08             hdif=hdifn
+ rsh=rshn                  rd=0                      rs=0
+ vth0=0.4752311+dvthn+vthmis                         lvth0=5.8255010e-09+dlvthn
+ wvth0=0+dwvthn            pvth0=0+dpvthn            k1=dk1n+0.4096095
+ lk1=4.8995580e-08         k2=5.9309460e-02+dk2n     lk2=-2.3341336e-08+dlk2n
+ k3=0.00                   dvt0=0.00                 dvt1=0.00
+ dvt2=0.00                 dvt0w=0.00                dvt1w=0.00
+ dvt2w=0.00                nlx=0.00                  w0=0.00
+ k3b=0.00                  vsat=8.4438960e04+dvsatn  wvsat=0+dwvsatn
+ lvsat=-2.0125005e-04      ua=-8.5891920e-10         lua=-1.0530929e-18
+ ub=2.6581962e-18          lub=5.5594780e-27         uc=1.1678118e-10
+ luc=4.1339190e-18         rdsw=drdswn+1.7000000e02  prwb=0.00
+ prwg=0.00                 wr=1.0000000              u0=du0n+4.3354470e-02
+ pu0=0+dpu0n               wu0=0+dwu0n               lu0=1.2517989e-09+dlu0n
+ a0=0.5407774              la0=7.5452710e-08         keta=-4.1823270e-02
+ lketa=2.9580252e-09       a1=0.00                   a2=0.9900000
+ ags=-1.9916179e-02        lags=-1.1735286e-11       b0=0.00
+ b1=0.00                   voff=-0.1245498+dvoffn    pvoff=0+dpvoffn
+ wvoff=0+dwvoffn           lvoff=-1.5463618e-09+dlvoffn
+ nfactor=1.0000000+dnfactorn                         pnfactor=0+dpnfactorn
+ wnfactor=0+dwnfactorn     lnfactor=0+dlnfactorn     cit=2.7188900e-04
+ lcit=1.0493098e-10        cdsc=0.00                 cdscb=0.00
+ cdscd=0.00                eta0=-2.9375020e-04+deta0n
+ peta0=0+dpeta0n           weta0=0+dweta0n           leta0=1.8112506e-10+dleta0n
+ etab=1.3875004e-03        letab=-6.8425020e-10      dsub=0.00
+ pclm=1.1076791            lpclm=4.2534670e-08       pdiblc1=1.0000000e-06
+ pdiblc2=-5.9354100e-03    lpdiblc2=5.0309570e-09    pdiblcb=1.0000000e-02
+ drout=0.00                pscbe1=4.0000000e08       pscbe2=1.0000000e-06
+ pvag=0.00                 delta=1.0000000e-02       alpha0=0.0
+ alpha1=0.448150714        beta0=11.59263            kt1=-0.2271500
+ lkt1=4.9185610e-09        kt2=-2.9537767e-02        lkt2=6.0297430e-10
+ at=2.0000000e04           ute=-2.0822308            lute=7.0304760e-08
+ ua1=1.2182583e-09         lua1=8.0390990e-19        ub1=-3.5266740e-18
+ lub1=3.8241010e-25        uc1=-1.3815420e-10        luc1=2.9606131e-17
+ kt1l=0.00                 prt=0                     cj=cjn
+ pb=0.6882682              mj=0.3595262              cjsw=cjswn
+ pbsw=0.6882682            mjsw=0.2003879            cjswg=cjswgn
+ pbswg=0.6882682           mjswg=0.43879             cgdo=cgon
+ cgso=cgon                 tcj=0.001040287           tcjsw=0.000645489
+ tcjswg=0.000645489        tpb=0.001554306           tpbsw=0.001554306
+ tpbswg=0.001554306        js=3.50e-07               jsw=1.45e-12
+ n=1                       xti=3                     capmod=3
+ nqsmod=0                  xpart=1                   cf=0
+ tlev=1                    tlevc=1                   dlc=3e-9
+ llc=-0.039                noimod=2                  ef=0.874
+ noia=2.0e+19              noib=1.2e4                noic=2.5e-13
+ em=3.0e+07                minr=1e-60                imax=0.01
+ imelt=0.01

     5: type=n
+ lmin=1.000e-05-dxln-dlmis lmax=20.001e-006          wmin=1.2000e-06-dxwn-dwmis
+ wmax=1.0000e-05-dxwn-dwmis                          tnom=25.0
+ version=3.24              tox=toxn+toxmis           toxm=4.08e-09
+ xj=1.6000000e-07          nch=3.9000000e17          lln=-1
+ lwn=1.0000000             wln=1.0000000             wwn=1
+ lint=1.0000000e-08        ll=0.00                   lw=0.00
+ lwl=0.00                  wint=3.0000000e-09        wl=0.00
+ ww=0.00                   wwl=0.00                  mobmod=1
+ binunit=2                 xl=-0.02e-6+dxln+dlmis    xw=0.0+dxwn+dwmis
+ dwg=0.00                  dwb=0.00                  ldif=9.00e-08
+ hdif=hdifn                rsh=rshn                  rd=0
+ rs=0                      vth0=0.4364873+dvthn+vthmis
+ wvth0=6.8761140e-10+dwvthn                          pvth0=0+dpvthn
+ lvth0=0+dlvthn            k1=dk1n+0.5102321         wk1=3.9956060e-08
+ k2=1.6091494e-02+dk2n     lk2=0+dlk2n               wk2=-1.2928737e-08
+ k3=0.00                   dvt0=0.00                 dvt1=0.00
+ dvt2=0.00                 dvt0w=0.00                dvt1w=0.00
+ dvt2w=0.00                nlx=0.00                  w0=0.00
+ k3b=0.00                  vsat=9.0000010e04+dvsatn  wvsat=0+dwvsatn
+ ua=-5.8859420e-10         wua=-2.3665659e-16        ub=2.3329335e-18
+ wub=-1.9367960e-25        uc=1.1057788e-10          wuc=-1.8159270e-17
+ rdsw=drdswn+1.7000000e02  prwb=0.00                 prwg=0.00
+ wr=1.0000000              u0=du0n+4.3035900e-02     pu0=0+dpu0n
+ wu0=-8.3200990e-09+dwu0n  lu0=0+dlu0n               a0=0.3702259
+ wa0=-1.4643313e-09        keta=1.0357677e-02        wketa=-1.0935369e-08
+ a1=0.00                   a2=0.9900000              ags=2.0000000e-02
+ b0=0.00                   b1=0.00                   voff=-0.1406671+dvoffn
+ pvoff=0+dpvoffn           lvoff=0+dlvoffn           wvoff=8.9072240e-10+dwvoffn
+ nfactor=1.0000000+dnfactorn                         pnfactor=0+dpnfactorn
+ wnfactor=0+dwnfactorn     lnfactor=0+dlnfactorn     cit=-1.0000001e-04
+ cdsc=0.00                 cdscb=0.00                cdscd=0.00
+ eta0=5.0000000e-05+deta0n peta0=0+dpeta0n           weta0=0+dweta0n
+ leta0=0+dleta0n           etab=-5.0000000e-05       dsub=0.00
+ pclm=0.8000001            pdiblc1=1.0000000e-06     pdiblc2=6.9999990e-04
+ pdiblcb=1.0000000e-02     drout=0.00                pscbe1=2.0000003e08
+ pscbe2=1.0000000e-06      pvag=0.00                 delta=1.0000000e-02
+ alpha0=0.0                alpha1=0.448150714        beta0=11.59263
+ kt1=-0.2232244            wkt1=-8.2151660e-09       kt2=-3.0428693e-02
+ wkt2=1.6245854e-09        at=2.0000000e04           ute=-1.5803809
+ wute=3.8084330e-09        ua1=1.2240000e-09         ub1=-1.0684574e-18
+ wub1=-5.2442470e-25       uc1=2.4230474e-11         wuc1=-1.2579110e-16
+ puc1=-1.4905616e-28       kt1l=0.00                 prt=0
+ cj=cjn                    pb=0.6882682              mj=0.3595262
+ cjsw=cjswn                pbsw=0.6882682            mjsw=0.2003879
+ cjswg=cjswgn              pbswg=0.6882682           mjswg=0.43879
+ cgdo=cgon                 cgso=cgon                 tcj=0.001040287
+ tcjsw=0.000645489         tcjswg=0.000645489        tpb=0.001554306
+ tpbsw=0.001554306         tpbswg=0.001554306        js=3.50e-07
+ jsw=1.45e-12              n=1                       xti=3
+ capmod=3                  nqsmod=0                  xpart=1
+ cf=0                      tlev=1                    tlevc=1
+ dlc=3e-9                  llc=-0.039                noimod=2
+ ef=0.874                  noia=2.0e+19              noib=1.2e4
+ noic=2.5e-13              em=3.0e+07                minr=1e-60
+ imax=0.01                 imelt=0.01

     6: type=n
+ lmin=1.200e-06-dxln-dlmis lmax=1.000e-05-dxln-dlmis wmin=1.2000e-06-dxwn-dwmis
+ wmax=1.0000e-05-dxwn-dwmis                          tnom=25.0
+ version=3.24              tox=toxn+toxmis           toxm=4.08e-09
+ xj=1.6000000e-07          nch=3.9000000e17          lln=-1
+ lwn=1.0000000             wln=1.0000000             wwn=1
+ lint=1.0000000e-08        ll=0.00                   lw=0.00
+ lwl=0.00                  wint=3.0000000e-09        wl=0.00
+ ww=0.00                   wwl=0.00                  mobmod=1
+ binunit=2                 xl=-0.02e-6+dxln+dlmis    xw=0.0+dxwn+dwmis
+ dwg=0.00                  dwb=0.00                  ldif=9.00e-08
+ hdif=hdifn                rsh=rshn                  rd=0
+ rs=0                      vth0=0.4303924+dvthn+vthmis
+ lvth0=6.0706090e-08+dlvthn                          wvth0=7.8115020e-10+dwvthn
+ pvth0=-9.3168750e-16+dpvthn                         k1=dk1n+0.5085090
+ lk1=1.7161611e-08         wk1=4.2216520e-08         pk1=-2.2514154e-14
+ k2=1.7310230e-02+dk2n     lk2=-1.2138612e-08+dlk2n  wk2=-1.3957471e-08
+ pk2=1.0246181e-14         k3=0.00                   dvt0=0.00
+ dvt1=0.00                 dvt2=0.00                 dvt0w=0.00
+ dvt1w=0.00                dvt2w=0.00                nlx=0.00
+ w0=0.00                   k3b=0.00                  vsat=9.0678020e04+dvsatn
+ lvsat=-6.7530250e-03      wvsat=-1.9104627e-04+dwvsatn
+ pvsat=1.9027204e-09       ua=-5.3771250e-10         lua=-5.0678040e-16
+ wua=-2.7926046e-16        pua=4.2433420e-22         ub=2.2537915e-18
+ lub=7.8825360e-25         wub=-1.4282058e-25        pub=-5.0655580e-31
+ uc=1.0657759e-10          luc=3.9842870e-17         wuc=-1.7297008e-17
+ puc=-8.5881340e-24        rdsw=drdswn+1.7000000e02  prwb=0.00
+ prwg=0.00                 wr=1.0000000              u0=du0n+4.2730270e-02
+ lu0=3.0440912e-09+dlu0n   wu0=-8.5686630e-09+dwu0n  pu0=2.4756895e-15+dpu0n
+ a0=0.4062600              la0=-3.5889950e-07        wa0=-1.0786144e-08
+ pa0=9.2845460e-14         keta=1.4894814e-02        lketa=-4.5189890e-08
+ wketa=-1.2924230e-08      pketa=1.9809019e-14       a1=0.00
+ a2=0.9900000              ags=2.0000000e-02         b0=0.00
+ b1=0.00                   voff=-0.1395822+dvoffn    lvoff=-1.0806052e-08+dlvoffn
+ wvoff=5.5485390e-10+dwvoffn                         pvoff=3.3452410e-15+dpvoffn
+ nfactor=1.0000000+dnfactorn                         pnfactor=0+dpnfactorn
+ wnfactor=0+dwnfactorn     lnfactor=0+dlnfactorn     cit=-1.2675911e-04
+ lcit=2.6652053e-10        cdsc=0.00                 cdscb=0.00
+ cdscd=0.00                eta0=5.0000000e-05+deta0n peta0=0+dpeta0n
+ weta0=0+dweta0n           leta0=0+dleta0n           etab=-5.0000000e-05
+ dsub=0.00                 pclm=0.7755287            lpclm=2.4373449e-07
+ wpclm=-1.9103656e-08      ppclm=1.9027247e-13       pdiblc1=1.0000000e-06
+ pdiblc2=3.9681810e-04     lpdiblc2=3.0196912e-09    pdiblcb=1.0000000e-02
+ drout=0.00                pscbe1=1.7363640e08       lpscbe1=2.6258185e02
+ pscbe2=1.0000000e-06      pvag=0.00                 delta=1.0000000e-02
+ alpha0=0.0                alpha1=0.448150714        beta0=11.59263
+ kt1=-0.2231775            lkt1=-4.6746150e-10       wkt1=-8.6881510e-09
+ pkt1=4.7109120e-15        kt2=-3.0469729e-02        lkt2=4.0873210e-10
+ wkt2=2.0392819e-09        pkt2=-4.1303770e-15       at=2.0000000e04
+ ute=-1.5809486            lute=5.6541540e-09        wute=9.5395260e-09
+ pute=-5.7081670e-14       ua1=1.2240000e-09         ub1=-1.0643074e-18
+ lub1=-4.1333620e-26       wub1=-5.6635370e-25       pub1=4.1761280e-31
+ uc1=2.4967807e-11         luc1=-7.3437550e-18       wuc1=-1.3323848e-16
+ puc1=7.4175780e-23        kt1l=0.00                 prt=0
+ cj=cjn                    pb=0.6882682              mj=0.3595262
+ cjsw=cjswn                pbsw=0.6882682            mjsw=0.2003879
+ cjswg=cjswgn              pbswg=0.6882682           mjswg=0.43879
+ cgdo=cgon                 cgso=cgon                 tcj=0.001040287
+ tcjsw=0.000645489         tcjswg=0.000645489        tpb=0.001554306
+ tpbsw=0.001554306         tpbswg=0.001554306        js=3.50e-07
+ jsw=1.45e-12              n=1                       xti=3
+ capmod=3                  nqsmod=0                  xpart=1
+ cf=0                      tlev=1                    tlevc=1
+ dlc=3e-9                  llc=-0.039                noimod=2
+ ef=0.874                  noia=2.0e+19              noib=1.2e4
+ noic=2.5e-13              em=3.0e+07                minr=1e-60
+ imax=0.01                 imelt=0.01

     7: type=n
+ lmin=5.000e-07-dxln-dlmis lmax=1.200e-06-dxln-dlmis wmin=1.2000e-06-dxwn-dwmis
+ wmax=1.0000e-05-dxwn-dwmis                          tnom=25.0
+ version=3.24              tox=toxn+toxmis           toxm=4.08e-09
+ xj=1.6000000e-07          nch=3.9000000e17          lln=-1
+ lwn=1.0000000             wln=1.0000000             wwn=1
+ lint=1.0000000e-08        ll=0.00                   lw=0.00
+ lwl=0.00                  wint=3.0000000e-09        wl=0.00
+ ww=0.00                   wwl=0.00                  mobmod=1
+ binunit=2                 xl=-0.02e-6+dxln+dlmis    xw=0.0+dxwn+dwmis
+ dwg=0.00                  dwb=0.00                  ldif=9.00e-08
+ hdif=hdifn                rsh=rshn                  rd=0
+ rs=0                      vth0=0.4799949+dvthn+vthmis
+ lvth0=3.1671320e-09+dlvthn                          wvth0=-6.7044360e-09+dwvthn
+ pvth0=7.7515980e-15+dpvthn                          k1=dk1n+0.5329412
+ lk1=-1.1179709e-08        wk1=-1.1356744e-08        pk1=3.9630840e-14
+ k2=3.8880950e-03+dk2n     lk2=3.4310650e-09+dlk2n   wk2=9.7623110e-09
+ pk2=-1.7268767e-14        k3=0.00                   dvt0=0.00
+ dvt1=0.00                 dvt2=0.00                 dvt0w=0.00
+ dvt1w=0.00                dvt2w=0.00                nlx=0.00
+ w0=0.00                   k3b=0.00                  vsat=8.5513590e04+dvsatn
+ lvsat=-7.6228650e-04      wvsat=1.4492224e-03+dwvsatn
+ ua=-1.0276002e-09         lua=6.1489260e-17         wua=-7.1467150e-17
+ pua=1.8329395e-22         ub=3.0435232e-18          lub=-1.2783527e-25
+ wub=-3.3419020e-25        pub=-2.8456703e-31        uc=1.4653272e-10
+ luc=-6.5050680e-18        wuc=2.5660584e-18         puc=-3.1629300e-23
+ rdsw=drdswn+1.7000000e02  prwb=0.00                 prwg=0.00
+ wr=1.0000000              u0=du0n+4.4526490e-02     lu0=9.6047130e-10+dlu0n
+ wu0=-7.1248670e-09+dwu0n  pu0=8.0088650e-16+dpu0n   a0=-0.3035701
+ la0=4.6450350e-07         wa0=1.2405528e-07         pa0=-6.3570630e-14
+ keta=-1.5493870e-02       lketa=-9.9390180e-09      wketa=-4.3336820e-09
+ pketa=9.8439870e-15       a1=0.00                   a2=0.9900000
+ ags=4.9808680e-02         lags=-3.4578080e-08       wags=-3.5591570e-08
+ pags=4.1286230e-14        b0=0.00                   b1=0.00
+ voff=-0.1627226+dvoffn    lvoff=1.6036822e-08+dlvoffn
+ wvoff=6.0367980e-09+dwvoffn                         pvoff=-3.0138140e-15+dpvoffn
+ nfactor=1.0000000+dnfactorn                         pnfactor=0+dpnfactorn
+ wnfactor=0+dwnfactorn     lnfactor=0+dlnfactorn     cit=-1.5788565e-04
+ lcit=3.0262734e-10        cdsc=0.00                 cdscb=0.00
+ cdscd=0.00                eta0=1.7142869e-05+deta0n peta0=0+dpeta0n
+ weta0=0+dweta0n           leta0=3.8114280e-11+dleta0n
+ etab=-1.7142869e-05       letab=-3.8114280e-11      dsub=0.00
+ pclm=0.8548421            lpclm=1.5173094e-07       wpclm=1.3866737e-07
+ ppclm=7.2580320e-15       pdiblc1=1.0000000e-06     pdiblc2=1.7737894e-03
+ lpdiblc2=1.4224044e-09    wpdiblc2=-8.8978950e-10   ppdiblc2=1.0321563e-15
+ pdiblcb=1.0000000e-02     drout=0.00                pscbe1=4.0000010e08
+ pscbe2=1.0000000e-06      pvag=0.00                 delta=1.0000000e-02
+ alpha0=0.0                alpha1=0.448150714        beta0=11.59263
+ kt1=-0.2286601            lkt1=5.8923870e-09        wkt1=-3.6818220e-09
+ pkt1=-1.0964308e-15       kt2=-3.1479932e-02        lkt2=1.5805686e-09
+ wkt2=-1.3190541e-09       pkt2=-2.3470743e-16       at=2.0000000e04
+ ute=-1.3089141            lute=-3.0990586e-07       wute=-4.1531240e-07
+ pute=4.3574660e-13        ua1=1.2269809e-09         lua1=-3.4577810e-18
+ wua1=-3.5591300e-18       pua1=4.1285910e-24        ub1=7.5674550e-20
+ lub1=-1.3637128e-24       wub1=-1.6132161e-24       pub1=1.6319734e-30
+ uc1=8.5944920e-11         luc1=-7.8077210e-17       wuc1=-1.8047248e-16
+ puc1=1.2896722e-22        kt1l=0.00                 prt=0
+ cj=cjn                    pb=0.6882682              mj=0.3595262
+ cjsw=cjswn                pbsw=0.6882682            mjsw=0.2003879
+ cjswg=cjswgn              pbswg=0.6882682           mjswg=0.43879
+ cgdo=cgon                 cgso=cgon                 tcj=0.001040287
+ tcjsw=0.000645489         tcjswg=0.000645489        tpb=0.001554306
+ tpbsw=0.001554306         tpbswg=0.001554306        js=3.50e-07
+ jsw=1.45e-12              n=1                       xti=3
+ capmod=3                  nqsmod=0                  xpart=1
+ cf=0                      tlev=1                    tlevc=1
+ dlc=3e-9                  llc=-0.039                noimod=2
+ ef=0.874                  noia=2.0e+19              noib=1.2e4
+ noic=2.5e-13              em=3.0e+07                minr=1e-60
+ imax=0.01                 imelt=0.01

     8: type=n
+ lmin=1.8e-007             lmax=5.000e-07-dxln-dlmis wmin=1.2000e-06-dxwn-dwmis
+ wmax=1.0000e-05-dxwn-dwmis                          tnom=25.0
+ version=3.24              tox=toxn+toxmis           toxm=4.08e-09
+ xj=1.6000000e-07          nch=3.9000000e17          lln=-1
+ lwn=1.0000000             wln=1.0000000             wwn=1
+ lint=1.0000000e-08        ll=0.00                   lw=0.00
+ lwl=0.00                  wint=3.0000000e-09        wl=0.00
+ ww=0.00                   wwl=0.00                  mobmod=1
+ binunit=2                 xl=-0.02e-6+dxln+dlmis    xw=0.0+dxwn+dwmis
+ dwg=0.00                  dwb=0.00                  ldif=9.00e-08
+ hdif=hdifn                rsh=rshn                  rd=0
+ rs=0                      vth0=0.4751966+dvthn+vthmis
+ lvth0=5.3743360e-09+dlvthn                          wvth0=3.4482360e-10+dwvthn
+ pvth0=4.5089380e-15+dpvthn                          k1=dk1n+0.4007356
+ lk1=4.9634880e-08         wk1=8.8686750e-08         pk1=-6.3891820e-15
+ k2=6.3188600e-02+dk2n     lk2=-2.3847164e-08+dlk2n  wk2=-3.8768180e-08
+ pk2=5.0552590e-15         k3=0.00                   dvt0=0.00
+ dvt1=0.00                 dvt2=0.00                 dvt0w=0.00
+ dvt1w=0.00                dvt2w=0.00                nlx=0.00
+ w0=0.00                   k3b=0.00                  vsat=8.4294280e04+dvsatn
+ lvsat=-2.0140363e-04      wvsat=1.4459029e-03+dwvsatn
+ pvsat=1.5350395e-12       ua=-9.0172960e-10         lua=3.5887640e-18
+ wua=4.2784730e-16         pua=-4.6390690e-23        ub=2.7527719e-18
+ lub=5.9103390e-27         wub=-9.4519130e-25        pub=-3.5064990e-33
+ uc=1.2291169e-10          luc=4.3605990e-18         wuc=-6.1268420e-17
+ puc=-2.2654354e-24        rdsw=drdswn+1.7000000e02  prwb=0.00
+ prwg=0.00                 wr=1.0000000              u0=du0n+4.3840840e-02
+ lu0=1.2758692e-09+dlu0n   wu0=-4.8608560e-09+dwu0n  pu0=-2.4055863e-16+dpu0n
+ a0=0.5262308              la0=8.2795080e-08         wa0=1.4537927e-07
+ pa0=-7.3379640e-14        keta=-4.4118840e-02       lketa=3.2284670e-09
+ wketa=2.2941933e-08       pketa=-2.7027957e-15      a1=0.00
+ a2=0.9900000              ags=-2.7693154e-02        lags=1.0727657e-09
+ wags=7.7723050e-08        pags=-1.0838496e-14       b0=0.00
+ b1=0.00                   voff=-0.1247105+dvoffn    lvoff=-1.4487617e-09+dlvoffn
+ wvoff=1.6054964e-09+dwvoffn                         pvoff=-9.7541500e-16+dpvoffn
+ nfactor=1.0000000+dnfactorn                         pnfactor=0+dpnfactorn
+ wnfactor=0+dwnfactorn     lnfactor=0+dlnfactorn     cit=2.7498236e-04
+ lcit=1.0350804e-10        wcit=-3.0914837e-11       pcit=1.4220811e-17
+ cdsc=0.00                 cdscb=0.00                cdscd=0.00
+ eta0=-2.9405078e-04+deta0n                          leta0=1.8126334e-10+dleta0n
+ weta0=3.0046217e-12+dweta0n                         peta0=-1.3821218e-18+dpeta0n
+ etab=1.3878694e-03        letab=-6.8441990e-10      wetab=-3.6866540e-12
+ petab=1.6959704e-18       dsub=0.00                 pclm=1.1010191
+ lpclm=3.8489530e-08       wpclm=6.6560680e-08       ppclm=4.0427110e-14
+ pdiblc1=1.0000000e-06     pdiblc2=-6.1190130e-03    lpdiblc2=5.0530930e-09
+ wpdiblc2=1.8349379e-09    ppdiblc2=-2.2121929e-16   pdiblcb=1.0000000e-02
+ drout=0.00                pscbe1=4.0000000e08       pscbe2=1.0000000e-06
+ pvag=0.00                 delta=1.0000000e-02       alpha0=0.0
+ alpha1=0.448150714        beta0=11.59263            kt1=-0.2269240
+ lkt1=5.0937890e-09        wkt1=-2.2583577e-09       pkt1=-1.7512235e-15
+ kt2=-2.9338669e-02        lkt2=5.9558730e-10        wkt2=-1.9897783e-09
+ pkt2=7.3825670e-17        at=2.0000000e04           ute=-2.1610963
+ lute=8.2097990e-08        wute=7.8818350e-07        pute=-1.1786150e-13
+ ua1=1.2174792e-09         lua1=9.1298580e-19        wua1=7.7858620e-18
+ pua1=-1.0901051e-24       ub1=-3.8124500e-18        lub1=4.2482470e-25
+ wub1=2.8560549e-24        pub1=-4.2389140e-31       uc1=-1.5406690e-10
+ luc1=3.2328220e-17        wuc1=1.5903152e-16        puc1=-2.7204607e-23
+ kt1l=0.00                 prt=0                     cj=cjn
+ pb=0.6882682              mj=0.3595262              cjsw=cjswn
+ pbsw=0.6882682            mjsw=0.2003879            cjswg=cjswgn
+ pbswg=0.6882682           mjswg=0.43879             cgdo=cgon
+ cgso=cgon                 tcj=0.001040287           tcjsw=0.000645489
+ tcjswg=0.000645489        tpb=0.001554306           tpbsw=0.001554306
+ tpbswg=0.001554306        js=3.50e-07               jsw=1.45e-12
+ n=1                       xti=3                     capmod=3
+ nqsmod=0                  xpart=1                   cf=0
+ tlev=1                    tlevc=1                   dlc=3e-9
+ llc=-0.039                noimod=2                  ef=0.874
+ noia=2.0e+19              noib=1.2e4                noic=2.5e-13
+ em=3.0e+07                minr=1e-60                imax=0.01
+ imelt=0.01

     9: type=n
+ lmin=1.000e-05-dxln-dlmis lmax=20.001e-006          wmin=5.0000e-07-dxwn-dwmis
+ wmax=1.2000e-06-dxwn-dwmis                          tnom=25.0
+ version=3.24              tox=toxn+toxmis           toxm=4.08e-09
+ xj=1.6000000e-07          nch=3.9000000e17          lln=-1
+ lwn=1.0000000             wln=1.0000000             wwn=1
+ lint=1.0000000e-08        ll=0.00                   lw=0.00
+ lwl=0.00                  wint=3.0000000e-09        wl=0.00
+ ww=0.00                   wwl=0.00                  mobmod=1
+ binunit=2                 xl=-0.02e-6+dxln+dlmis    xw=0.0+dxwn+dwmis
+ dwg=0.00                  dwb=0.00                  ldif=9.00e-08
+ hdif=hdifn                rsh=rshn                  rd=0
+ rs=0                      vth0=0.4406337+dvthn+vthmis
+ wvth0=-4.2631090e-09+dwvthn                         pvth0=0+dpvthn
+ lvth0=0+dlvthn            k1=dk1n+0.5610723         wk1=-2.0747230e-08
+ k2=1.1422717e-03+dk2n     lk2=0+dlk2n               wk2=4.9206340e-09
+ k3=0.00                   dvt0=0.00                 dvt1=0.00
+ dvt2=0.00                 dvt0w=0.00                dvt1w=0.00
+ dvt2w=0.00                nlx=0.00                  w0=0.00
+ k3b=0.00                  vsat=9.0000010e04+dvsatn  wvsat=0+dwvsatn
+ ua=-9.0664090e-10         wua=1.4309126e-16         ub=2.2997995e-18
+ wub=-1.5411778e-25        uc=1.0721270e-10          wuc=-1.4141237e-17
+ rdsw=drdswn+1.7000000e02  prwb=0.00                 prwg=0.00
+ wr=1.0000000              u0=du0n+3.5199720e-02     pu0=0+dpu0n
+ wu0=1.0362965e-09+dwu0n   lu0=0+dlu0n               a0=0.3047864
+ wa0=7.6670510e-08         keta=1.0152902e-03        wketa=2.1944087e-10
+ a1=0.00                   a2=0.9900000              ags=2.0000000e-02
+ b0=0.00                   b1=0.00                   voff=-0.1391954+dvoffn
+ pvoff=0+dpvoffn           lvoff=0+dlvoffn           wvoff=-8.6656900e-10+dwvoffn
+ nfactor=1.0000000+dnfactorn                         pnfactor=0+dpnfactorn
+ wnfactor=0+dwnfactorn     lnfactor=0+dlnfactorn     cit=-1.0000004e-04
+ cdsc=0.00                 cdscb=0.00                cdscd=0.00
+ eta0=5.0000000e-05+deta0n peta0=0+dpeta0n           weta0=0+dweta0n
+ leta0=0+dleta0n           etab=-5.0000000e-05       dsub=0.00
+ pclm=0.8000001            pdiblc1=1.0000000e-06     pdiblc2=7.0000030e-04
+ pdiblcb=1.0000000e-02     drout=0.00                pscbe1=2.0000003e08
+ pscbe2=1.0000000e-06      pvag=0.00                 delta=1.0000000e-02
+ alpha0=0.0                alpha1=0.448150714        beta0=11.59263
+ kt1=-0.2313184            wkt1=1.4490446e-09        kt2=-2.9076951e-02
+ wkt2=1.0605161e-11        at=2.0000000e04           ute=-1.6093186
+ wute=3.8360070e-08        ua1=1.2240000e-09         ub1=-1.5012456e-18
+ wub1=-7.6755530e-27       uc1=-6.8805160e-11        wuc1=-1.4706552e-17
+ kt1l=0.00                 prt=0                     cj=cjn
+ pb=0.6882682              mj=0.3595262              cjsw=cjswn
+ pbsw=0.6882682            mjsw=0.2003879            cjswg=cjswgn
+ pbswg=0.6882682           mjswg=0.43879             cgdo=cgon
+ cgso=cgon                 tcj=0.001040287           tcjsw=0.000645489
+ tcjswg=0.000645489        tpb=0.001554306           tpbsw=0.001554306
+ tpbswg=0.001554306        js=3.50e-07               jsw=1.45e-12
+ n=1                       xti=3                     capmod=3
+ nqsmod=0                  xpart=1                   cf=0
+ tlev=1                    tlevc=1                   dlc=3e-9
+ llc=-0.039                noimod=2                  ef=0.874
+ noia=2.0e+19              noib=1.2e4                noic=2.5e-13
+ em=3.0e+07                minr=1e-60                imax=0.01
+ imelt=0.01

     10: type=n
+ lmin=1.200e-06-dxln-dlmis lmax=1.000e-05-dxln-dlmis wmin=5.0000e-07-dxwn-dwmis
+ wmax=1.2000e-06-dxwn-dwmis                          tnom=25.0
+ version=3.24              tox=toxn+toxmis           toxm=4.08e-09
+ xj=1.6000000e-07          nch=3.9000000e17          lln=-1
+ lwn=1.0000000             wln=1.0000000             wwn=1
+ lint=1.0000000e-08        ll=0.00                   lw=0.00
+ lwl=0.00                  wint=3.0000000e-09        wl=0.00
+ ww=0.00                   wwl=0.00                  mobmod=1
+ binunit=2                 xl=-0.02e-6+dxln+dlmis    xw=0.0+dxwn+dwmis
+ dwg=0.00                  dwb=0.00                  ldif=9.00e-08
+ hdif=hdifn                rsh=rshn                  rd=0
+ rs=0                      vth0=0.4340151+dvthn+vthmis
+ lvth0=6.5920480e-08+dlvthn                          wvth0=-3.5444660e-09+dwvthn
+ pvth0=-7.1576720e-15+dpvthn                         k1=dk1n+0.5600169
+ lk1=1.0512358e-08         wk1=-1.9283881e-08        pk1=-1.4574950e-14
+ k2=1.6854487e-03+dk2n     lk2=-5.4100510e-09+dlk2n  wk2=4.6985170e-09
+ pk2=2.2122807e-15         k3=0.00                   dvt0=0.00
+ dvt1=0.00                 dvt2=0.00                 dvt0w=0.00
+ dvt1w=0.00                dvt2w=0.00                nlx=0.00
+ w0=0.00                   k3b=0.00                  vsat=9.0622610e04+dvsatn
+ lvsat=-6.2011020e-03      wvsat=-1.2487893e-04+dwvsatn
+ pvsat=1.2437262e-09       ua=-8.8743970e-10         lua=-1.9124487e-16
+ wua=1.3831368e-16         pua=4.7584710e-23         ub=2.2584638e-18
+ lub=4.1170380e-25         wub=-1.4839938e-25        pub=-5.6955330e-32
+ uc=1.0315766e-10          luc=4.0388150e-17         wuc=-1.3213606e-17
+ puc=-9.2391890e-24        rdsw=drdswn+1.7000000e02  prwb=0.00
+ prwg=0.00                 wr=1.0000000              u0=du0n+3.4827660e-02
+ lu0=3.7057520e-09+dlu0n   wu0=8.6705280e-10+dwu0n   pu0=1.6856667e-15+dpu0n
+ a0=0.3245910              la0=-1.9725388e-07        wa0=8.6726660e-08
+ pa0=-1.0015934e-13        keta=3.8292700e-03        lketa=-2.8027248e-08
+ wketa=2.8803285e-10       pketa=-6.8318020e-16      a1=0.00
+ a2=0.9900000              ags=2.0000000e-02         b0=0.00
+ b1=0.00                   voff=-0.1388337+dvoffn    lvoff=-3.6022220e-09+dlvoffn
+ wvoff=-3.3884450e-10+dwvoffn                        pvoff=-5.2561320e-15+dpvoffn
+ nfactor=1.0000000+dnfactorn                         pnfactor=0+dpnfactorn
+ wnfactor=0+dwnfactorn     lnfactor=0+dlnfactorn     cit=-1.2672294e-04
+ lcit=2.6616018e-10        wcit=-4.3173710e-14       pcit=4.3027530e-19
+ cdsc=0.00                 cdscb=0.00                cdscd=0.00
+ eta0=5.0000000e-05+deta0n peta0=0+dpeta0n           weta0=0+dweta0n
+ leta0=0+dleta0n           etab=-5.0000000e-05       dsub=0.00
+ pclm=0.7699873            lpclm=2.9892766e-07       wpclm=-1.2487239e-08
+ ppclm=1.2437180e-13       pdiblc1=1.0000000e-06     pdiblc2=3.9681850e-04
+ lpdiblc2=3.0196912e-09    pdiblcb=1.0000000e-02     drout=0.00
+ pscbe1=1.7363640e08       lpscbe1=2.6258185e02      pscbe2=1.0000000e-06
+ pvag=0.00                 delta=1.0000000e-02       alpha0=0.0
+ alpha1=0.448150714        beta0=11.59263            kt1=-0.2310088
+ lkt1=-3.0828107e-09       wkt1=6.6253410e-10        pkt1=7.8336390e-15
+ kt2=-2.8688708e-02        lkt2=-3.8668810e-09       wkt2=-8.7256760e-11
+ pkt2=9.7470440e-16        at=2.0000000e04           ute=-1.6080947
+ lute=-1.2190513e-08       wute=4.1951950e-08        pute=-3.5775140e-14
+ ua1=1.2240000e-09         ub1=-1.5338095e-18        lub1=3.2433570e-25
+ wub1=-5.7682950e-27       pub1=-1.8996434e-32       uc1=-7.3164090e-11
+ luc1=4.3414890e-17        wuc1=-1.6068998e-17       puc1=1.3569954e-23
+ kt1l=0.00                 prt=0                     cj=cjn
+ pb=0.6882682              mj=0.3595262              cjsw=cjswn
+ pbsw=0.6882682            mjsw=0.2003879            cjswg=cjswgn
+ pbswg=0.6882682           mjswg=0.43879             cgdo=cgon
+ cgso=cgon                 tcj=0.001040287           tcjsw=0.000645489
+ tcjswg=0.000645489        tpb=0.001554306           tpbsw=0.001554306
+ tpbswg=0.001554306        js=3.50e-07               jsw=1.45e-12
+ n=1                       xti=3                     capmod=3
+ nqsmod=0                  xpart=1                   cf=0
+ tlev=1                    tlevc=1                   dlc=3e-9
+ llc=-0.039                noimod=2                  ef=0.874
+ noia=2.0e+19              noib=1.2e4                noic=2.5e-13
+ em=3.0e+07                minr=1e-60                imax=0.01
+ imelt=0.01

     11: type=n
+ lmin=5.000e-07-dxln-dlmis lmax=1.200e-06-dxln-dlmis wmin=5.0000e-07-dxwn-dwmis
+ wmax=1.2000e-06-dxwn-dwmis                          tnom=25.0
+ version=3.24              tox=toxn+toxmis           toxm=4.08e-09
+ xj=1.6000000e-07          nch=3.9000000e17          lln=-1
+ lwn=1.0000000             wln=1.0000000             wwn=1
+ lint=1.0000000e-08        ll=0.00                   lw=0.00
+ lwl=0.00                  wint=3.0000000e-09        wl=0.00
+ ww=0.00                   wwl=0.00                  mobmod=1
+ binunit=2                 xl=-0.02e-6+dxln+dlmis    xw=0.0+dxwn+dwmis
+ dwg=0.00                  dwb=0.00                  ldif=9.00e-08
+ hdif=hdifn                rsh=rshn                  rd=0
+ rs=0                      vth0=0.4821278+dvthn+vthmis
+ lvth0=1.0109751e-08+dlvthn                          wvth0=-9.2511780e-09+dwvthn
+ pvth0=-5.3788820e-16+dpvthn                         k1=dk1n+0.5552615
+ lk1=1.6028618e-08         wk1=-3.8007200e-08        pk1=7.1440980e-15
+ k2=3.5447990e-03+dk2n     lk2=-7.5668960e-09+dlk2n  wk2=1.0172209e-08
+ pk2=-4.1372030e-15        k3=0.00                   dvt0=0.00
+ dvt1=0.00                 dvt2=0.00                 dvt0w=0.00
+ dvt1w=0.00                dvt2w=0.00                nlx=0.00
+ w0=0.00                   k3b=0.00                  vsat=8.5937130e04+dvsatn
+ lvsat=-7.6594880e-04      wvsat=9.4352240e-04+dwvsatn
+ pvsat=4.3808180e-12       ua=-1.3333591e-09         lua=3.2602160e-16
+ wua=2.9360883e-16         pua=-1.3255767e-22        ub=2.9690860e-18
+ lub=-4.1261800e-25        wub=-2.4531215e-25        pub=5.5463480e-32
+ uc=1.6160392e-10          luc=-2.7409531e-17        wuc=-1.5428970e-17
+ puc=-6.6693660e-24        rdsw=drdswn+1.7000000e02  prwb=0.00
+ prwg=0.00                 wr=1.0000000              u0=du0n+3.5811860e-02
+ lu0=2.5640821e-09+dlu0n   wu0=3.2804070e-09+dwu0n   pu0=-1.1138246e-15+dpu0n
+ a0=-0.1914371             la0=4.0133880e-07         wa0=-9.8314440e-09
+ pa0=1.1848049e-14         keta=-1.7824383e-02       lketa=-2.9090079e-09
+ wketa=-1.5510503e-09      pketa=1.4501565e-15       a1=0.00
+ a2=0.9900000              ags=2.0000000e-02         b0=0.00
+ b1=0.00                   voff=-0.1515625+dvoffn    lvoff=1.1163230e-08+dlvoffn
+ wvoff=-7.2883150e-09+dwvoffn                        pvoff=2.8052535e-15+dpvoffn
+ nfactor=1.0000000+dnfactorn                         pnfactor=0+dpnfactorn
+ wnfactor=0+dwnfactorn     lnfactor=0+dlnfactorn     cit=-1.5834050e-04
+ lcit=3.0283653e-10        wcit=5.4312310e-13        pcit=-2.4980728e-19
+ cdsc=0.00                 cdscb=0.00                cdscd=0.00
+ eta0=1.7142847e-05+deta0n peta0=0+dpeta0n           weta0=0+dweta0n
+ leta0=3.8114300e-11+dleta0n                         etab=-1.7142847e-05
+ letab=-3.8114300e-11      dsub=0.00                 pclm=0.9444105
+ lpclm=9.6596760e-08       wpclm=3.1722750e-08       ppclm=7.3088240e-14
+ pdiblc1=1.0000000e-06     pdiblc2=1.1219129e-03     lpdiblc2=2.1785818e-09
+ wpdiblc2=-1.1144895e-10   ppdiblc2=1.2928064e-16    pdiblcb=1.0000000e-02
+ drout=0.00                pscbe1=4.0000010e08       pscbe2=1.0000000e-06
+ pvag=0.00                 delta=1.0000000e-02       alpha0=0.0
+ alpha1=0.448150714        beta0=11.59263            kt1=-0.2417087
+ lkt1=9.3290630e-09        wkt1=1.1898274e-08        pkt1=-5.1998210e-15
+ kt2=-3.4342460e-02        lkt2=2.6914670e-09        wkt2=2.0987987e-09
+ pkt2=-1.5611203e-15       at=2.0000000e04           ute=-1.8126432
+ lute=2.2508574e-07        wute=1.8614003e-07        pute=-2.0303331e-13
+ ua1=1.2240000e-09         ub1=-1.6810433e-18        lub1=4.9512690e-25
+ wub1=4.8430470e-25        pub1=-5.8748110e-31       uc1=-8.8066520e-11
+ luc1=6.0701720e-17        wuc1=2.7297169e-17        puc1=-3.6734800e-23
+ kt1l=0.00                 prt=0                     cj=cjn
+ pb=0.6882682              mj=0.3595262              cjsw=cjswn
+ pbsw=0.6882682            mjsw=0.2003879            cjswg=cjswgn
+ pbswg=0.6882682           mjswg=0.43879             cgdo=cgon
+ cgso=cgon                 tcj=0.001040287           tcjsw=0.000645489
+ tcjswg=0.000645489        tpb=0.001554306           tpbsw=0.001554306
+ tpbswg=0.001554306        js=3.50e-07               jsw=1.45e-12
+ n=1                       xti=3                     capmod=3
+ nqsmod=0                  xpart=1                   cf=0
+ tlev=1                    tlevc=1                   dlc=3e-9
+ llc=-0.039                noimod=2                  ef=0.874
+ noia=2.0e+19              noib=1.2e4                noic=2.5e-13
+ em=3.0e+07                minr=1e-60                imax=0.01
+ imelt=0.01

     12: type=n
+ lmin=1.8e-007             lmax=5.000e-07-dxln-dlmis wmin=5.0000e-07-dxwn-dwmis
+ wmax=1.2000e-06-dxwn-dwmis                          tnom=25.0
+ version=3.24              tox=toxn+toxmis           toxm=4.08e-09
+ xj=1.6000000e-07          nch=3.9000000e17          lln=-1
+ lwn=1.0000000             wln=1.0000000             wwn=1
+ lint=1.0000000e-08        ll=0.00                   lw=0.00
+ lwl=0.00                  wint=3.0000000e-09        wl=0.00
+ ww=0.00                   wwl=0.00                  mobmod=1
+ binunit=2                 xl=-0.02e-6+dxln+dlmis    xw=0.0+dxwn+dwmis
+ dwg=0.00                  dwb=0.00                  ldif=9.00e-08
+ hdif=hdifn                rsh=rshn                  rd=0
+ rs=0                      vth0=0.4891579+dvthn+vthmis
+ lvth0=6.8759450e-09+dlvthn                          wvth0=-1.6324883e-08+dwvthn
+ pvth0=2.7160160e-15+dpvthn                          k1=dk1n+0.4899670
+ lk1=4.6064080e-08         wk1=-1.7855582e-08        pk1=-2.1256446e-15
+ k2=2.9298484e-02+dk2n     lk2=-1.9413593e-08+dlk2n  wk2=1.6966123e-09
+ pk2=-2.3842633e-16        k3=0.00                   dvt0=0.00
+ dvt1=0.00                 dvt2=0.00                 dvt0w=0.00
+ dvt1w=0.00                dvt2w=0.00                nlx=0.00
+ w0=0.00                   k3b=0.00                  vsat=8.4736300e04+dvsatn
+ lvsat=-2.1356932e-04      wvsat=9.1813100e-04+dwvsatn
+ pvsat=1.6060880e-11       ua=-5.2740020e-10         lua=-4.4719440e-17
+ wua=-1.9101984e-17        pua=1.1289303e-23         ub=2.0039751e-18
+ lub=3.1333025e-26         wub=-5.1128100e-26        pub=-3.3861180e-32
+ uc=7.9146470e-11          luc=1.0520902e-17         wuc=-9.0127290e-18
+ puc=-9.6208370e-24        rdsw=drdswn+1.7000000e02  prwb=0.00
+ prwg=0.00                 wr=1.0000000              u0=du0n+3.9805520e-02
+ lu0=7.2699450e-10+dlu0n   wu0=-4.2684650e-11+dwu0n  pu0=4.1479770e-16+dpu0n
+ a0=0.5005398              la0=8.3029360e-08         wa0=1.7605426e-07
+ pa0=-7.3659360e-14        keta=-2.7587207e-02       lketa=1.5818911e-09
+ wketa=3.2031690e-09       pketa=-7.3678430e-16      a1=0.00
+ a2=0.9900000              ags=4.0857530e-02         lags=-9.5944640e-09
+ wags=-4.1264700e-09       pags=1.8981756e-15        b0=0.00
+ b1=0.00                   voff=-0.1264125+dvoffn    lvoff=-4.0576950e-10+dlvoffn
+ wvoff=3.6377740e-09+dwvoffn                         pvoff=-2.2207474e-15+dpvoffn
+ nfactor=1.0000000+dnfactorn                         pnfactor=0+dpnfactorn
+ wnfactor=0+dwnfactorn     lnfactor=0+dlnfactorn     cit=2.2317801e-04
+ lcit=1.2733804e-10        wcit=3.0939650e-11        pcit=-1.4232223e-17
+ cdsc=0.00                 cdscb=0.00                cdscd=0.00
+ eta0=-3.1223928e-04+deta0n                          leta0=1.8963006e-10+dleta0n
+ weta0=2.4721704e-11+dweta0n                         peta0=-1.1371991e-17+dpeta0n
+ etab=1.4101875e-03        letab=-6.9468620e-10      wetab=-3.0334849e-11
+ petab=1.3954016e-17       dsub=0.00                 pclm=0.9948969
+ lpclm=7.3373010e-08       wpclm=1.9327061e-07       ppclm=-1.2237712e-15
+ pdiblc1=1.0000000e-06     pdiblc2=-4.0132200e-03    lpdiblc2=4.5407440e-09
+ wpdiblc2=-6.7937070e-10   ppdiblc2=3.9052370e-16    pdiblcb=1.0000000e-02
+ drout=0.00                pscbe1=4.0000000e08       pscbe2=1.0000000e-06
+ pvag=0.00                 delta=1.0000000e-02       alpha0=0.0
+ alpha1=0.448150714        beta0=11.59263            kt1=-0.2249505
+ lkt1=1.6202869e-09        wkt1=-4.6146780e-09       pkt1=2.3961372e-15
+ kt2=-2.8312566e-02        lkt2=-8.2282570e-11       wkt2=-3.2149460e-09
+ pkt2=8.8320210e-16        at=2.0000000e04           ute=-1.2073984
+ lute=-5.3326850e-08       wute=-3.5053180e-07       pute=4.3835750e-14
+ ua1=1.2240000e-09         ub1=-4.6211320e-19        lub1=-6.5580890e-26
+ wub1=-1.1442477e-24       pub1=1.6165291e-31        uc1=6.0016960e-11
+ luc1=-7.4166880e-18       wuc1=-9.6584590e-17       puc1=2.0250814e-23
+ kt1l=0.00                 prt=0                     cj=cjn
+ pb=0.6882682              mj=0.3595262              cjsw=cjswn
+ pbsw=0.6882682            mjsw=0.2003879            cjswg=cjswgn
+ pbswg=0.6882682           mjswg=0.43879             cgdo=cgon
+ cgso=cgon                 tcj=0.001040287           tcjsw=0.000645489
+ tcjswg=0.000645489        tpb=0.001554306           tpbsw=0.001554306
+ tpbswg=0.001554306        js=3.50e-07               jsw=1.45e-12
+ n=1                       xti=3                     capmod=3
+ nqsmod=0                  xpart=1                   cf=0
+ tlev=1                    tlevc=1                   dlc=3e-9
+ llc=-0.039                noimod=2                  ef=0.874
+ noia=2.0e+19              noib=1.2e4                noic=2.5e-13
+ em=3.0e+07                minr=1e-60                imax=0.01
+ imelt=0.01

     13: type=n
+ lmin=1.000e-05-dxln-dlmis lmax=20.001e-006          wmin=2.2e-007
+ wmax=5.0000e-07-dxwn-dwmis                          tnom=25.0
+ version=3.24              tox=toxn+toxmis           toxm=4.08e-09
+ xj=1.6000000e-07          nch=3.9000000e17          lln=-1
+ lwn=1.0000000             wln=1.0000000             wwn=1
+ lint=1.0000000e-08        ll=0.00                   lw=0.00
+ lwl=0.00                  wint=3.0000000e-09        wl=0.00
+ ww=0.00                   wwl=0.00                  mobmod=1
+ binunit=2                 xl=-0.02e-6+dxln+dlmis    xw=0.0+dxwn+dwmis
+ dwg=0.00                  dwb=0.00                  ldif=9.00e-08
+ hdif=hdifn                rsh=rshn                  rd=0
+ rs=0                      vth0=0.4632908+dvthn+vthmis
+ wvth0=-1.5455745e-08+dwvthn                         pvth0=0+dpvthn
+ lvth0=0+dlvthn            k1=dk1n+0.5220979         wk1=-1.4938487e-09
+ k2=1.6542569e-02+dk2n     lk2=0+dlk2n               wk2=-2.6871128e-09
+ k3=0.00                   dvt0=0.00                 dvt1=0.00
+ dvt2=0.00                 dvt0w=0.00                dvt1w=0.00
+ dvt2w=0.00                nlx=0.00                  w0=0.00
+ k3b=0.00                  vsat=8.9999990e04+dvsatn  wvsat=0+dwvsatn
+ ua=-5.8606080e-10         wua=-1.5275344e-17        ub=1.7266676e-18
+ wub=1.2900942e-25         uc=7.2522020e-11          wuc=2.9959555e-18
+ rdsw=drdswn+1.7000000e02  prwb=0.00                 prwg=0.00
+ wr=1.0000000              u0=du0n+3.5337420e-02     pu0=0+dpu0n
+ wu0=9.6827260e-10+dwu0n   lu0=0+dlu0n               a0=0.3529820
+ wa0=5.2861860e-08         keta=2.0642520e-03        wketa=-2.9874625e-10
+ a1=0.00                   a2=0.9900000              ags=2.0000000e-02
+ b0=0.00                   b1=0.00                   voff=-0.1374522+dvoffn
+ pvoff=0+dpvoffn           lvoff=0+dlvoffn           wvoff=-1.7276782e-09+dwvoffn
+ nfactor=1.0000000+dnfactorn                         pnfactor=0+dpnfactorn
+ wnfactor=0+dwnfactorn     lnfactor=0+dlnfactorn     cit=-9.9999980e-05
+ cdsc=0.00                 cdscb=0.00                cdscd=0.00
+ eta0=5.0000000e-05+deta0n peta0=0+dpeta0n           weta0=0+dweta0n
+ leta0=0+dleta0n           etab=-5.0000000e-05       dsub=0.00
+ pclm=0.7999999            pdiblc1=1.0000000e-06     pdiblc2=6.9999990e-04
+ pdiblcb=1.0000000e-02     drout=0.00                pscbe1=2.0000003e08
+ pscbe2=1.0000000e-06      pvag=0.00                 delta=1.0000000e-02
+ alpha0=0.0                alpha1=0.448150714        beta0=11.59263
+ kt1=-0.2387670            wkt1=5.1286530e-09        kt2=-3.6205880e-02
+ wkt2=3.5322950e-09        at=2.0000000e04           ute=-1.5833832
+ wute=2.5547985e-08        ua1=1.2240000e-09         ub1=-1.4270478e-18
+ wub1=-4.4329310e-26       uc1=-6.3987300e-11        wuc1=-1.7086574e-17
+ kt1l=0.00                 prt=0                     cj=cjn
+ pb=0.6882682              mj=0.3595262              cjsw=cjswn
+ pbsw=0.6882682            mjsw=0.2003879            cjswg=cjswgn
+ pbswg=0.6882682           mjswg=0.43879             cgdo=cgon
+ cgso=cgon                 tcj=0.001040287           tcjsw=0.000645489
+ tcjswg=0.000645489        tpb=0.001554306           tpbsw=0.001554306
+ tpbswg=0.001554306        js=3.50e-07               jsw=1.45e-12
+ n=1                       xti=3                     capmod=3
+ nqsmod=0                  xpart=1                   cf=0
+ tlev=1                    tlevc=1                   dlc=3e-9
+ llc=-0.039                noimod=2                  ef=0.874
+ noia=2.0e+19              noib=1.2e4                noic=2.5e-13
+ em=3.0e+07                minr=1e-60                imax=0.01
+ imelt=0.01

     14: type=n
+ lmin=1.200e-06-dxln-dlmis lmax=1.000e-05-dxln-dlmis wmin=2.2e-007
+ wmax=5.0000e-07-dxwn-dwmis                          tnom=25.0
+ version=3.24              tox=toxn+toxmis           toxm=4.08e-09
+ xj=1.6000000e-07          nch=3.9000000e17          lln=-1
+ lwn=1.0000000             wln=1.0000000             wwn=1
+ lint=1.0000000e-08        ll=0.00                   lw=0.00
+ lwl=0.00                  wint=3.0000000e-09        wl=0.00
+ ww=0.00                   wwl=0.00                  mobmod=1
+ binunit=2                 xl=-0.02e-6+dxln+dlmis    xw=0.0+dxwn+dwmis
+ dwg=0.00                  dwb=0.00                  ldif=9.00e-08
+ hdif=hdifn                rsh=rshn                  rd=0
+ rs=0                      vth0=0.4576404+dvthn+vthmis
+ lvth0=5.6278240e-08+dlvthn                          wvth0=-1.5215344e-08+dwvthn
+ pvth0=-2.3944025e-15+dpvthn                         k1=dk1n+0.5284545
+ lk1=-6.3312430e-08        wk1=-3.6920920e-09        pk1=2.1894499e-14
+ k2=1.4454342e-02+dk2n     lk2=2.0798732e-08+dlk2n   wk2=-1.6093152e-09
+ pk2=-1.0734859e-14        k3=0.00                   dvt0=0.00
+ dvt1=0.00                 dvt2=0.00                 dvt0w=0.00
+ dvt1w=0.00                dvt2w=0.00                nlx=0.00
+ w0=0.00                   k3b=0.00                  vsat=9.0528880e04+dvsatn
+ lvsat=-5.2677570e-03      wvsat=-7.8579540e-05+dwvsatn
+ pvsat=7.8265330e-10       ua=-5.7313250e-10         lua=-1.2876533e-16
+ wua=-1.6954039e-17        pua=1.6719826e-23         ub=1.6479914e-18
+ lub=7.8361630e-25         wub=1.5317406e-25         pub=-2.4068014e-31
+ uc=6.5429030e-11          luc=7.0646260e-17         wuc=5.4243400e-18
+ puc=-2.4186704e-23        rdsw=drdswn+1.7000000e02  prwb=0.00
+ prwg=0.00                 wr=1.0000000              u0=du0n+3.4344000e-02
+ lu0=9.8945550e-09+dlu0n   wu0=1.1059835e-09+dwu0n   pu0=-1.3716021e-15+dpu0n
+ a0=0.3780467              la0=-2.4964379e-07        wa0=6.0319560e-08
+ pa0=-7.4278730e-14        keta=5.1141510e-03        lketa=-3.0377027e-08
+ wketa=-3.4669910e-10      pketa=4.7761250e-16       a1=0.00
+ a2=0.9900000              ags=2.0000000e-02         b0=0.00
+ b1=0.00                   voff=-0.1354716+dvoffn    lvoff=-1.9727372e-08+dlvoffn
+ wvoff=-1.9997353e-09+dwvoffn                        pvoff=2.7096929e-15+dpvoffn
+ nfactor=1.0000000+dnfactorn                         pnfactor=0+dpnfactorn
+ wnfactor=0+dwnfactorn     lnfactor=0+dlnfactorn     cit=-1.2649217e-04
+ lcit=2.6386249e-10        wcit=-1.5715551e-13       pcit=1.5653096e-18
+ cdsc=0.00                 cdscb=0.00                cdscd=0.00
+ eta0=5.0000000e-05+deta0n peta0=0+dpeta0n           weta0=0+dweta0n
+ leta0=0+dleta0n           etab=-5.0000000e-05       dsub=0.00
+ pclm=0.7606163            lpclm=3.9226100e-07       wpclm=-7.8579230e-09
+ ppclm=7.8265150e-14       pdiblc1=1.0000000e-06     pdiblc2=3.9681830e-04
+ lpdiblc2=3.0196909e-09    pdiblcb=1.0000000e-02     drout=0.00
+ pscbe1=1.7363640e08       lpscbe1=2.6258182e02      pscbe2=1.0000000e-06
+ pvag=0.00                 delta=1.0000000e-02       alpha0=0.0
+ alpha1=0.448150714        beta0=11.59263            kt1=-0.2407974
+ lkt1=2.0222748e-08        wkt1=5.4980620e-09        pkt1=-3.6793080e-15
+ kt2=-3.5896250e-02        lkt2=-3.0839447e-09       wkt2=3.4732650e-09
+ pkt2=5.8793360e-16        at=2.0000000e04           ute=-1.5785241
+ lute=-4.8396960e-08       wute=2.7344081e-08        pute=-1.7889165e-14
+ ua1=1.2240000e-09         ub1=-1.4513121e-18        lub1=2.4167225e-25
+ wub1=-4.6522010e-26       pub1=2.1839324e-32        uc1=-6.9917860e-11
+ luc1=5.9068390e-17        wuc1=-1.7672629e-17       puc1=5.8371280e-24
+ kt1l=0.00                 prt=0                     cj=cjn
+ pb=0.6882682              mj=0.3595262              cjsw=cjswn
+ pbsw=0.6882682            mjsw=0.2003879            cjswg=cjswgn
+ pbswg=0.6882682           mjswg=0.43879             cgdo=cgon
+ cgso=cgon                 tcj=0.001040287           tcjsw=0.000645489
+ tcjswg=0.000645489        tpb=0.001554306           tpbsw=0.001554306
+ tpbswg=0.001554306        js=3.50e-07               jsw=1.45e-12
+ n=1                       xti=3                     capmod=3
+ nqsmod=0                  xpart=1                   cf=0
+ tlev=1                    tlevc=1                   dlc=3e-9
+ llc=-0.039                noimod=2                  ef=0.874
+ noia=2.0e+19              noib=1.2e4                noic=2.5e-13
+ em=3.0e+07                minr=1e-60                imax=0.01
+ imelt=0.01

     15: type=n
+ lmin=5.000e-07-dxln-dlmis lmax=1.200e-06-dxln-dlmis wmin=2.2e-007
+ wmax=5.0000e-07-dxwn-dwmis                          tnom=25.0
+ version=3.24              tox=toxn+toxmis           toxm=4.08e-09
+ xj=1.6000000e-07          nch=3.9000000e17          lln=-1
+ lwn=1.0000000             wln=1.0000000             wwn=1
+ lint=1.0000000e-08        ll=0.00                   lw=0.00
+ lwl=0.00                  wint=3.0000000e-09        wl=0.00
+ ww=0.00                   wwl=0.00                  mobmod=1
+ binunit=2                 xl=-0.02e-6+dxln+dlmis    xw=0.0+dxwn+dwmis
+ dwg=0.00                  dwb=0.00                  ldif=9.00e-08
+ hdif=hdifn                rsh=rshn                  rd=0
+ rs=0                      vth0=0.4985188+dvthn+vthmis
+ lvth0=8.8592590e-09+dlvthn                          wvth0=-1.7348324e-08+dwvthn
+ pvth0=7.9854650e-17+dpvthn                          k1=dk1n+0.4140751
+ lk1=6.9367740e-08         wk1=3.1738890e-08         pk1=-1.9205430e-14
+ k2=5.9564120e-02+dk2n     lk2=-3.1528607e-08+dlk2n  wk2=-1.7501334e-08
+ pk2=7.6998830e-15         k3=0.00                   dvt0=0.00
+ dvt1=0.00                 dvt2=0.00                 dvt0w=0.00
+ dvt1w=0.00                dvt2w=0.00                nlx=0.00
+ w0=0.00                   k3b=0.00                  vsat=8.6668210e04+dvsatn
+ lvsat=-7.8937880e-04      wvsat=5.8236690e-04+dwvsatn
+ pvsat=1.5955267e-11       ua=-7.3702990e-10         lua=6.1355590e-17
+ wua=-9.7776210e-19        pua=-1.8126578e-24        ub=2.5777392e-18
+ lub=-2.9489129e-25        wub=-5.1986800e-26        pub=-2.6935000e-33
+ uc=1.4975288e-10          luc=-2.7169401e-17        wuc=-9.5745500e-18
+ puc=-6.7879900e-24        rdsw=drdswn+1.7000000e02  prwb=0.00
+ prwg=0.00                 wr=1.0000000              u0=du0n+4.4377760e-02
+ lu0=-1.7446106e-09+dlu0n  wu0=-9.5114710e-10+dwu0n  pu0=1.0146696e-15+dpu0n
+ a0=-7.7693450e-02         la0=2.7901473e-07         wa0=-6.6020820e-08
+ pa0=7.2276130e-14         keta=-1.5611105e-02       lketa=-6.3357300e-09
+ wketa=-2.6444102e-09      pketa=3.1429577e-15       a1=0.00
+ a2=0.9900000              ags=2.0000000e-02         b0=0.00
+ b1=0.00                   voff=-0.1694116+dvoffn    lvoff=1.9643004e-08+dlvoffn
+ wvoff=1.5290980e-09+dwvoffn                         pvoff=-1.3837542e-15+dpvoffn
+ nfactor=1.0000000+dnfactorn                         pnfactor=0+dpnfactorn
+ wnfactor=0+dwnfactorn     lnfactor=0+dlnfactorn     cit=-1.6124053e-04
+ lcit=3.0417063e-10        wcit=1.9757180e-12        pcit=-9.0883360e-19
+ cdsc=0.00                 cdscb=0.00                cdscd=0.00
+ eta0=1.7142866e-05+deta0n peta0=0+dpeta0n           weta0=0+dweta0n
+ leta0=3.8114280e-11+dleta0n                         etab=-1.7142866e-05
+ letab=-3.8114280e-11      dsub=0.00                 pclm=0.9728217
+ lpclm=1.4610272e-07       wpclm=1.7687656e-08       ppclm=4.8632290e-14
+ pdiblc1=1.0000000e-06     pdiblc2=1.7171376e-03     lpdiblc2=1.4881204e-09
+ wpdiblc2=-4.0549010e-10   ppdiblc2=4.7036850e-16    pdiblcb=1.0000000e-02
+ drout=0.00                pscbe1=4.0000010e08       pscbe2=1.0000000e-06
+ pvag=0.00                 delta=1.0000000e-02       alpha0=0.0
+ alpha1=0.448150714        beta0=11.59263            kt1=-0.2426658
+ lkt1=2.2390124e-08        wkt1=1.2371058e-08        pkt1=-1.1651986e-14
+ kt2=-4.0695580e-02        lkt2=2.4832894e-09        wkt2=5.2372430e-09
+ pkt2=-1.4582807e-15       at=2.0000000e04           ute=-1.4758356
+ lute=-1.6751561e-07       wute=1.9757099e-08        pute=-9.0882650e-15
+ ua1=1.2240000e-09         ub1=-4.8661160e-19        lub1=-8.7738050e-25
+ wub1=-1.0574451e-25       pub1=9.0537450e-32        uc1=4.8991040e-11
+ luc1=-7.8865980e-17       wuc1=-4.0409280e-17       puc1=3.2211650e-23
+ kt1l=0.00                 prt=0                     cj=cjn
+ pb=0.6882682              mj=0.3595262              cjsw=cjswn
+ pbsw=0.6882682            mjsw=0.2003879            cjswg=cjswgn
+ pbswg=0.6882682           mjswg=0.43879             cgdo=cgon
+ cgso=cgon                 tcj=0.001040287           tcjsw=0.000645489
+ tcjswg=0.000645489        tpb=0.001554306           tpbsw=0.001554306
+ tpbswg=0.001554306        js=3.50e-07               jsw=1.45e-12
+ n=1                       xti=3                     capmod=3
+ nqsmod=0                  xpart=1                   cf=0
+ tlev=1                    tlevc=1                   dlc=3e-9
+ llc=-0.039                noimod=2                  ef=0.874
+ noia=2.0e+19              noib=1.2e4                noic=2.5e-13
+ em=3.0e+07                minr=1e-60                imax=0.01
+ imelt=0.01

     16: type=n
+ lmin=1.8e-007             lmax=5.000e-07-dxln-dlmis wmin=2.2e-007
+ wmax=5.0000e-07-dxwn-dwmis                          tnom=25.0
+ version=3.24              tox=toxn+toxmis           toxm=4.08e-09
+ xj=1.6000000e-07          nch=3.9000000e17          lln=-1
+ lwn=1.0000000             wln=1.0000000             wwn=1
+ lint=1.0000000e-08        ll=0.00                   lw=0.00
+ lwl=0.00                  wint=3.0000000e-09        wl=0.00
+ ww=0.00                   wwl=0.00                  mobmod=1
+ binunit=2                 xl=-0.02e-6+dxln+dlmis    xw=0.0+dxwn+dwmis
+ dwg=0.00                  dwb=0.00                  ldif=9.00e-08
+ hdif=hdifn                rsh=rshn                  rd=0
+ rs=0                      vth0=0.4862920+dvthn+vthmis
+ lvth0=1.4483583e-08+dlvthn                          wvth0=-1.4909164e-08+dwvthn
+ pvth0=-1.0421574e-15+dpvthn                         k1=dk1n+0.4942783
+ lk1=3.2474290e-08         wk1=-1.9985334e-08        pk1=4.5877080e-15
+ k2=2.3518253e-02+dk2n     lk2=-1.4947512e-08+dlk2n  wk2=4.5520450e-09
+ pk2=-2.4446703e-15        k3=0.00                   dvt0=0.00
+ dvt1=0.00                 dvt2=0.00                 dvt0w=0.00
+ dvt1w=0.00                dvt2w=0.00                nlx=0.00
+ w0=0.00                   k3b=0.00                  vsat=8.5400580e04+dvsatn
+ lvsat=-2.0626588e-04      wvsat=5.8998060e-04+dwvsatn
+ pvsat=1.2452966e-11       ua=-6.6143480e-10         lua=2.6581833e-17
+ wua=4.7111080e-17         pua=-2.3933522e-23        ub=2.1301375e-18
+ lub=-8.8994460e-26        wub=-1.1345223e-25        pub=2.5580594e-32
+ uc=1.2526492e-10          luc=-1.5904941e-17        wuc=-3.1795240e-17
+ puc=3.4335290e-24         rdsw=drdswn+1.7000000e02  prwb=0.00
+ prwg=0.00                 wr=1.0000000              u0=du0n+3.7103500e-02
+ lu0=1.6015452e-09+dlu0n   wu0=1.2921135e-09+dwu0n   pu0=-1.7230291e-17+dpu0n
+ a0=0.2707940              la0=1.1871046e-07         wa0=2.8954867e-07
+ pa0=-9.1285820e-14        keta=-3.0443965e-02       lketa=4.8738500e-10
+ wketa=4.6144070e-09       pketa=-1.9609824e-16      a1=0.00
+ a2=0.9900000              ags=5.4803800e-02         lags=-1.6009743e-08
+ wags=-1.1015922e-08       pags=5.0673230e-15        b0=0.00
+ b1=0.00                   voff=-0.1182414+dvoffn    lvoff=-3.8952710e-09+dlvoffn
+ wvoff=-3.9877300e-10+dwvoffn                        pvoff=-4.9693370e-16+dpvoffn
+ nfactor=1.0000000+dnfactorn                         pnfactor=0+dpnfactorn
+ wnfactor=0+dwnfactorn     lnfactor=0+dlnfactorn     cit=2.9138371e-04
+ lcit=9.5963440e-11        wcit=-2.7539906e-12       pcit=1.2668360e-18
+ cdsc=0.00                 cdscb=0.00                cdscd=0.00
+ eta0=-2.6219533e-04+deta0n                          peta0=0+dpeta0n
+ weta0=0+dweta0n           leta0=1.6660984e-10+dleta0n
+ etab=1.3487812e-03        letab=-6.6643920e-10      dsub=0.00
+ pclm=1.1355271            lpclm=7.1258150e-08       wpclm=1.2379924e-07
+ ppclm=-1.7902992e-16      pdiblc1=1.0000000e-06     pdiblc2=-7.1402370e-03
+ lpdiblc2=5.5625120e-09    wpdiblc2=8.6537500e-10    ppdiblc2=-1.1422951e-16
+ pdiblcb=1.0000000e-02     drout=0.00                pscbe1=4.0000000e08
+ pscbe2=1.0000000e-06      pvag=0.00                 delta=1.0000000e-02
+ alpha0=0.0                alpha1=0.448150714        beta0=11.59263
+ kt1=-0.1929406            lkt1=-4.8343960e-10       wkt1=-2.0427562e-08
+ pkt1=3.4353780e-15        kt2=-3.9379210e-02        lkt2=1.8777602e-09
+ wkt2=2.2519782e-09        pkt2=-8.5058880e-17       at=2.0000000e04
+ ute=-1.9466008            lute=4.9036400e-08        wute=1.4634106e-08
+ pute=-6.7316880e-15       ua1=1.2240000e-09         ub1=-3.1027764e-18
+ lub1=3.2605530e-25        wub1=1.6023990e-25        pub1=-3.1815360e-32
+ uc1=-2.4653823e-10        luc1=5.7077470e-17        wuc1=5.4853660e-17
+ puc1=-1.1609298e-23       kt1l=0.00                 prt=0
+ cj=cjn                    pb=0.6882682              mj=0.3595262
+ cjsw=cjswn                pbsw=0.6882682            mjsw=0.2003879
+ cjswg=cjswgn              pbswg=0.6882682           mjswg=0.43879
+ cgdo=cgon                 cgso=cgon                 tcj=0.001040287
+ tcjsw=0.000645489         tcjswg=0.000645489        tpb=0.001554306
+ tpbsw=0.001554306         tpbswg=0.001554306        js=3.50e-07
+ jsw=1.45e-12              n=1                       xti=3
+ capmod=3                  nqsmod=0                  xpart=1
+ cf=0                      tlev=1                    tlevc=1
+ dlc=3e-9                  llc=-0.039                noimod=2
+ ef=0.874                  noia=2.0e+19              noib=1.2e4
+ noic=2.5e-13              em=3.0e+07                minr=1e-60
+ imax=0.01                 imelt=0.01

     }
ends nch_mis

subckt pch_mis ( d g s b )
parameters l=18.e-08 w=1.5e-6 multi=1 ad=2*hdifp*w as=2*hdifp*w pd=2*(2*hdifp+w) ps=2*(2*hdifp+w) nrd=hdifp/w nrs=hdifp/w
+ lef=l - 20e-9 wef=w geo_fac=1 / sqrt(multi
+ * lef * wef * 1e12) vthmis=4.432e-3 * geo_fac * vthpmis dlmis=3.96e-3 * geo_fac
+ * lef * dlpmis dwmis=3.26e-3 * geo_fac * wef * dwpmis toxmis=8.73e-4 * geo_fac
+ * toxp * toxpmis

m0 ( d g s b ) pchmis w=w l=l ad=ad as=as pd=pd ps=ps nrd=nrd nrs=nrs m=multi

model pchmis bsim3v3  {
     1: type=p
+ lmin=1.000e-05-dxlp-dlmis lmax=20.001e-006          wmin=1.0000e-05-dxwp-dwmis
+ wmax=900.001e-6           tnom=25.0                 version=3.24
+ tox=toxp+toxmis           toxm=4.08e-09             xj=1.7000001e-07
+ nch=3.9000000e17          lln=-1                    lwn=1.0000000
+ wln=1.0000000             wwn=1.0000000             lint=1.4999999e-08
+ ll=0.00                   lw=0.00                   lwl=0.00
+ wint=5.0000000e-09        wl=0.00                   ww=0.00
+ wwl=0.00                  mobmod=1                  binunit=2
+ xl=-0.02e-6+dxlp+dlmis    xw=0.0+dxwp+dwmis         dwg=0.00
+ dwb=0.00                  ldif=9.00e-08             hdif=hdifp
+ rsh=rshp                  rd=0                      rs=0
+ vth0=-0.4384811+dvthp+vthmis                        k1=0.5375325
+ k2=3.5032560e-02+dk2p     lk2=0+dlk2p               pvth0=0+dpvthp
+ wvth0=0+dwvthp            lvth0=0+dlvthp            k3=0.00
+ dvt0=0.00                 dvt1=0.00                 dvt2=0.00
+ dvt0w=0.00                dvt1w=0.00                dvt2w=0.00
+ nlx=0.00                  w0=0.00                   k3b=0.00
+ vsat=1.4999998e05+dvsatp  wvsat=0+dwvsatp           ua=8.2329400e-10
+ ub=6.8543220e-19          uc=-8.6554110e-11         rdsw=5.3000000e02
+ prwb=0.00                 prwg=0.00                 wr=1.0000000
+ u0=1.0865118e-02+du0p     pu0=0+dpu0p               wu0=0+dwu0p
+ lu0=0+dlu0p               a0=1.0461572              keta=2.6632193e-02
+ a1=0.00                   a2=0.4000000              ags=2.0000000e-02
+ b0=0.00                   b1=0.00                   voff=-0.1275921+dvoffp
+ pvoff=0+dpvoffp           wvoff=0+dwvoffp           lvoff=0+dlvoffp
+ nfactor=1.0000000+dnfactorp                         pnfactor=0+dpnfactorp
+ wnfactor=0+dwnfactorp     lnfactor=0+dlnfactorp     cit=-1.0000000e-04
+ cdsc=0.00                 cdscb=0.00                cdscd=0.00
+ eta0=5.0000000e-05+deta0p peta0=0+dpeta0p           weta0=0+dweta0p
+ leta0=0+dleta0p           etab=-5.0000000e-05       dsub=0.00
+ pclm=0.6000001            pdiblc1=1.0000000e-06     pdiblc2=1.0000003e-03
+ pdiblcb=1.0000000e-02     drout=0.00                pscbe1=1.9999997e08
+ pscbe2=5.0000000e-07      pvag=0.00                 delta=1.0000000e-02
+ alpha0=0.00               alpha1=6.8730453846       beta0=22.67827
+ kt1=-0.2311294            kt2=-2.4339920e-02        at=1.0000000e04
+ ute=-0.8288856            ua1=1.2240000e-09         ub1=-1.3928839e-18
+ uc1=-4.5946700e-12        kt1l=0.00                 prt=0
+ cj=cjp                    pb=0.895226               mj=0.4476
+ cjsw=cjswp                pbsw=0.895226             mjsw=0.3683619
+ cjswg=cjswgp              pbswg=0.895226            mjswg=0.3683619
+ cgdo=cgop                 cgso=cgop                 tcj=0.0009739001
+ tcjsw=0.0004130718        tcjswg=0.0004130718       tpb=0.001572025
+ tpbsw=0.001572025         tpbswg=0.001572025        js=2.50e-07
+ jsw=1.2e-12               n=1                       xti=3
+ capmod=3                  nqsmod=0                  xpart=1
+ cf=0                      tlev=1                    tlevc=1
+ dlc=2e-9                  llc=-0.039                noimod=2
+ ef=1.064                  noia=9.5e+18              noib=1.0e5
+ noic=1.4e-12              em=3.0e+07                minr=1e-60
+ imax=0.01                 imelt=0.01

     2: type=p
+ lmin=1.200e-06-dxlp-dlmis lmax=1.000e-05-dxlp-dlmis wmin=1.0000e-05-dxwp-dwmis
+ wmax=900.001e-6           tnom=25.0                 version=3.24
+ tox=toxp+toxmis           toxm=4.08e-09             xj=1.7000001e-07
+ nch=3.9000000e17          lln=-1                    lwn=1.0000000
+ wln=1.0000000             wwn=1.0000000             lint=1.4999999e-08
+ ll=0.00                   lw=0.00                   lwl=0.00
+ wint=5.0000000e-09        wl=0.00                   ww=0.00
+ wwl=0.00                  mobmod=1                  binunit=2
+ xl=-0.02e-6+dxlp+dlmis    xw=0.0+dxwp+dwmis         dwg=0.00
+ dwb=0.00                  ldif=9.00e-08             hdif=hdifp
+ rsh=rshp                  rd=0                      rs=0
+ vth0=-0.4359872+dvthp+vthmis                        pvth0=0+dpvthp
+ wvth0=0+dwvthp            lvth0=-2.4814053e-08+dlvthp
+ k1=0.5356447              lk1=1.8783622e-08         k2=3.5584030e-02+dk2p
+ lk2=-5.4871720e-09+dlk2p  k3=0.00                   dvt0=0.00
+ dvt1=0.00                 dvt2=0.00                 dvt0w=0.00
+ dvt1w=0.00                dvt2w=0.00                nlx=0.00
+ w0=0.00                   k3b=0.00                  vsat=1.5130680e05+dvsatp
+ wvsat=0+dwvsatp           lvsat=-1.3002843e-02      ua=8.6253130e-10
+ lua=-3.9041110e-16        ub=6.4019980e-19          lub=4.5006260e-25
+ uc=-8.8551450e-11         luc=1.9873557e-17         rdsw=5.3000000e02
+ prwb=0.00                 prwg=0.00                 wr=1.0000000
+ u0=1.0995165e-02+du0p     pu0=0+dpu0p               wu0=0+dwu0p
+ lu0=-1.2939689e-09+dlu0p  a0=1.0385712              la0=7.5481240e-08
+ keta=2.6837848e-02        lketa=-2.0462676e-09      a1=0.00
+ a2=0.4000000              ags=2.0000000e-02         b0=0.00
+ b1=0.00                   voff=-0.1274002+dvoffp    pvoff=0+dpvoffp
+ wvoff=0+dwvoffp           lvoff=-1.9091309e-09+dlvoffp
+ nfactor=1.0000000+dnfactorp                         pnfactor=0+dpnfactorp
+ wnfactor=0+dwnfactorp     lnfactor=0+dlnfactorp     cit=-1.0000000e-04
+ cdsc=0.00                 cdscb=0.00                cdscd=0.00
+ eta0=5.0000000e-05+deta0p peta0=0+dpeta0p           weta0=0+dweta0p
+ leta0=0+dleta0p           etab=-5.0000000e-05       dsub=0.00
+ pclm=0.5738637            lpclm=2.6005682e-07       pdiblc1=1.0000000e-06
+ pdiblc2=4.7727270e-04     lpdiblc2=5.2011370e-09    pdiblcb=1.0000000e-02
+ drout=0.00                pscbe1=1.8039768e08       lpscbe1=1.9504263e02
+ pscbe2=5.0000000e-07      pvag=0.00                 delta=1.0000000e-02
+ alpha0=0.00               alpha1=6.8730453846       beta0=22.67827
+ kt1=-0.2295883            lkt1=-1.5333228e-08       kt2=-2.4031118e-02
+ lkt2=-3.0725886e-09       at=1.0000000e04           ute=-0.8385549
+ lute=9.6209720e-08        ua1=1.2240000e-09         ub1=-1.3977103e-18
+ lub1=4.8023260e-26        uc1=-6.6949180e-12        luc1=2.0897466e-17
+ kt1l=0.00                 prt=0                     cj=cjp
+ pb=0.895226               mj=0.4476                 cjsw=cjswp
+ pbsw=0.895226             mjsw=0.3683619            cjswg=cjswgp
+ pbswg=0.895226            mjswg=0.3683619           cgdo=cgop
+ cgso=cgop                 tcj=0.0009739001          tcjsw=0.0004130718
+ tcjswg=0.0004130718       tpb=0.001572025           tpbsw=0.001572025
+ tpbswg=0.001572025        js=2.50e-07               jsw=1.2e-12
+ n=1                       xti=3                     capmod=3
+ nqsmod=0                  xpart=1                   cf=0
+ tlev=1                    tlevc=1                   dlc=2e-9
+ llc=-0.039                noimod=2                  ef=1.064
+ noia=9.5e+18              noib=1.0e5                noic=1.4e-12
+ em=3.0e+07                minr=1e-60                imax=0.01
+ imelt=0.01

     3: type=p
+ lmin=5.000e-07-dxlp-dlmis lmax=1.200e-06-dxlp-dlmis wmin=1.0000e-05-dxwp-dwmis
+ wmax=900.001e-6           tnom=25.0                 version=3.24
+ tox=toxp+toxmis           toxm=4.08e-09             xj=1.7000001e-07
+ nch=3.9000000e17          lln=-1                    lwn=1.0000000
+ wln=1.0000000             wwn=1.0000000             lint=1.4999999e-08
+ ll=0.00                   lw=0.00                   lwl=0.00
+ wint=5.0000000e-09        wl=0.00                   ww=0.00
+ wwl=0.00                  mobmod=1                  binunit=2
+ xl=-0.02e-6+dxlp+dlmis    xw=0.0+dxwp+dwmis         dwg=0.00
+ dwb=0.00                  ldif=9.00e-08             hdif=hdifp
+ rsh=rshp                  rd=0                      rs=0
+ vth0=-0.4517478+dvthp+vthmis                        pvth0=0+dpvthp
+ wvth0=0+dwvthp            lvth0=-6.6894420e-09+dlvthp
+ k1=0.5405614              lk1=1.3129389e-08         k2=3.4901570e-02+dk2p
+ lk2=-4.7023350e-09+dlk2p  k3=0.00                   dvt0=0.00
+ dvt1=0.00                 dvt2=0.00                 dvt0w=0.00
+ dvt1w=0.00                dvt2w=0.00                nlx=0.00
+ w0=0.00                   k3b=0.00                  vsat=1.4642853e05+dvsatp
+ wvsat=0+dwvsatp           lvsat=-7.3928330e-03      ua=5.2669400e-10
+ lua=-4.1981250e-18        ub=1.1734415e-18          lub=-1.6316540e-25
+ uc=-4.3321150e-11         luc=-3.2141290e-17        rdsw=5.3000000e02
+ prwb=0.00                 prwg=0.00                 wr=1.0000000
+ u0=1.0224584e-02+du0p     pu0=0+dpu0p               wu0=0+dwu0p
+ lu0=-4.0780060e-10+dlu0p  a0=1.0045335              la0=1.1462460e-07
+ keta=3.2152590e-02        lketa=-8.1582250e-09      a1=0.00
+ a2=0.4000000              ags=2.0000000e-02         b0=0.00
+ b1=0.00                   voff=-0.1282353+dvoffp    pvoff=0+dpvoffp
+ wvoff=0+dwvoffp           lvoff=-9.4878250e-10+dlvoffp
+ nfactor=1.0000000+dnfactorp                         pnfactor=0+dpnfactorp
+ wnfactor=0+dwnfactorp     lnfactor=0+dlnfactorp     cit=-2.9480609e-04
+ lcit=2.2402701e-10        cdsc=0.00                 cdscb=0.00
+ cdscd=0.00                eta0=1.7857143e-05+deta0p peta0=0+dpeta0p
+ weta0=0+dweta0p           leta0=3.6964280e-11+dleta0p
+ etab=-1.7857143e-05       letab=-3.6964280e-11      dsub=0.00
+ pclm=0.6714287            lpclm=1.4785704e-07       pdiblc1=1.0000000e-06
+ pdiblc2=1.7857148e-03     lpdiblc2=3.6964280e-09    pdiblcb=1.0000000e-02
+ drout=0.00                pscbe1=3.4999990e08       pscbe2=5.0000000e-07
+ pvag=0.00                 delta=1.0000000e-02       alpha0=0.00
+ alpha1=6.8730453846       beta0=22.67827            kt1=-0.2442909
+ lkt1=1.5747348e-09        kt2=-2.7549893e-02        lkt2=9.7400280e-10
+ at=1.0000000e04           ute=-0.7866690            lute=3.6540920e-08
+ ua1=1.2240000e-09         ub1=-1.3827429e-18        lub1=3.0810812e-26
+ uc1=-1.4394627e-11        luc1=2.9752128e-17        kt1l=0.00
+ prt=0                     cj=cjp                    pb=0.895226
+ mj=0.4476                 cjsw=cjswp                pbsw=0.895226
+ mjsw=0.3683619            cjswg=cjswgp              pbswg=0.895226
+ mjswg=0.3683619           cgdo=cgop                 cgso=cgop
+ tcj=0.0009739001          tcjsw=0.0004130718        tcjswg=0.0004130718
+ tpb=0.001572025           tpbsw=0.001572025         tpbswg=0.001572025
+ js=2.50e-07               jsw=1.2e-12               n=1
+ xti=3                     capmod=3                  nqsmod=0
+ xpart=1                   cf=0                      tlev=1
+ tlevc=1                   dlc=2e-9                  llc=-0.039
+ noimod=2                  ef=1.064                  noia=9.5e+18
+ noib=1.0e5                noic=1.4e-12              em=3.0e+07
+ minr=1e-60                imax=0.01                 imelt=0.01

     4: type=p
+ lmin=1.8e-007             lmax=5.000e-07-dxlp-dlmis wmin=1.0000e-05-dxwp-dwmis
+ wmax=900.001e-6           tnom=25.0                 version=3.24
+ tox=toxp+toxmis           toxm=4.08e-09             xj=1.7000001e-07
+ nch=3.9000000e17          lln=-1                    lwn=1.0000000
+ wln=1.0000000             wwn=1.0000000             lint=1.4999999e-08
+ ll=0.00                   lw=0.00                   lwl=0.00
+ wint=5.0000000e-09        wl=0.00                   ww=0.00
+ wwl=0.00                  mobmod=1                  binunit=2
+ xl=-0.02e-6+dxlp+dlmis    xw=0.0+dxwp+dwmis         dwg=0.00
+ dwb=0.00                  ldif=9.00e-08             hdif=hdifp
+ rsh=rshp                  rd=0                      rs=0
+ vth0=-0.4483009+dvthp+vthmis                        pvth0=0+dpvthp
+ wvth0=0+dwvthp            lvth0=-8.2405520e-09+dlvthp
+ k1=0.5323869              lk1=1.6807924e-08         k2=3.7510190e-02+dk2p
+ lk2=-5.8762150e-09+dlk2p  k3=0.00                   dvt0=0.00
+ dvt1=0.00                 dvt2=0.00                 dvt0w=0.00
+ dvt1w=0.00                dvt2w=0.00                nlx=0.00
+ w0=0.00                   k3b=0.00                  vsat=1.3081252e05+dvsatp
+ wvsat=0+dwvsatp           lvsat=-3.6562650e-04      ua=8.7289950e-10
+ lua=-1.5999061e-16        ub=5.3978560e-19          lub=1.2197973e-25
+ uc=-1.5585878e-10         luc=1.8500639e-17         rdsw=5.3000000e02
+ prwb=0.00                 prwg=0.00                 wr=1.0000000
+ u0=9.5382440e-03+du0p     pu0=0+dpu0p               wu0=0+dwu0p
+ lu0=-9.8947810e-11+dlu0p  a0=1.2232625              la0=1.6196543e-08
+ keta=1.5869336e-02        lketa=-8.3075950e-10      a1=0.00
+ a2=0.4000000              ags=2.0000000e-02         b0=0.00
+ b1=0.00                   voff=-0.1302643+dvoffp    pvoff=0+dpvoffp
+ wvoff=0+dwvoffp           lvoff=-3.5715920e-11+dlvoffp
+ nfactor=1.0000000+dnfactorp                         pnfactor=0+dpnfactorp
+ wnfactor=0+dwnfactorp     lnfactor=0+dlnfactorp     cit=-4.0543960e-05
+ lcit=1.0960905e-10        cdsc=0.00                 cdscb=0.00
+ cdscd=-8.1250000e-05      lcdscd=3.6562500e-11      eta0=-4.6875020e-04+deta0p
+ peta0=0+dpeta0p           weta0=0+dweta0p           leta0=2.5593752e-10+dleta0p
+ etab=1.0775371e-03        letab=-5.2989170e-10      dsub=0.00
+ pclm=0.9102259            lpclm=4.0398300e-08       pdiblc1=1.0000000e-06
+ pdiblc2=7.9687500e-03     lpdiblc2=9.1406260e-10    pdiblcb=1.0000000e-02
+ drout=0.00                pscbe1=3.5000000e08       pscbe2=5.0000000e-07
+ pvag=0.00                 delta=1.0000000e-02       alpha0=0.00
+ alpha1=6.8730453846       beta0=22.67827            kt1=-0.2348693
+ lkt1=-2.6650000e-09       kt2=-2.4868647e-02        lkt2=-2.3255770e-10
+ at=1.0000000e04           ute=-0.7090256            lute=1.6013461e-09
+ ua1=1.2240000e-09         ub1=-1.3783631e-18        lub1=2.8839880e-26
+ uc1=6.6936230e-11         luc1=-6.8467590e-18       kt1l=0.00
+ prt=0                     cj=cjp                    pb=0.895226
+ mj=0.4476                 cjsw=cjswp                pbsw=0.895226
+ mjsw=0.3683619            cjswg=cjswgp              pbswg=0.895226
+ mjswg=0.3683619           cgdo=cgop                 cgso=cgop
+ tcj=0.0009739001          tcjsw=0.0004130718        tcjswg=0.0004130718
+ tpb=0.001572025           tpbsw=0.001572025         tpbswg=0.001572025
+ js=2.50e-07               jsw=1.2e-12               n=1
+ xti=3                     capmod=3                  nqsmod=0
+ xpart=1                   cf=0                      tlev=1
+ tlevc=1                   dlc=2e-9                  llc=-0.039
+ noimod=2                  ef=1.064                  noia=9.5e+18
+ noib=1.0e5                noic=1.4e-12              em=3.0e+07
+ minr=1e-60                imax=0.01                 imelt=0.01

     5: type=p
+ lmin=1.000e-05-dxlp-dlmis lmax=20.001e-006          wmin=1.2000e-06-dxwp-dwmis
+ wmax=1.0000e-05-dxwp-dwmis                          tnom=25.0
+ version=3.24              tox=toxp+toxmis           toxm=4.08e-09
+ xj=1.7000001e-07          nch=3.9000000e17          lln=-1
+ lwn=1.0000000             wln=1.0000000             wwn=1.0000000
+ lint=1.4999999e-08        ll=0.00                   lw=0.00
+ lwl=0.00                  wint=5.0000000e-09        wl=0.00
+ ww=0.00                   wwl=0.00                  mobmod=1
+ binunit=2                 xl=-0.02e-6+dxlp+dlmis    xw=0.0+dxwp+dwmis
+ dwg=0.00                  dwb=0.00                  ldif=9.00e-08
+ hdif=hdifp                rsh=rshp                  rd=0
+ rs=0                      vth0=-0.4397694+dvthp+vthmis
+ pvth0=0+dpvthp            wvth0=1.2870458e-08+dwvthp
+ k1=0.5362856              lvth0=0+dlvthp            wk1=1.2456701e-08
+ k2=3.5627170e-02+dk2p     lk2=0+dlk2p               wk2=-5.9401430e-09
+ k3=0.00                   dvt0=0.00                 dvt1=0.00
+ dvt2=0.00                 dvt0w=0.00                dvt1w=0.00
+ dvt2w=0.00                nlx=0.00                  w0=0.00
+ k3b=0.00                  vsat=1.4999998e05+dvsatp  wvsat=0+dwvsatp
+ ua=8.0573260e-10          wua=1.7543858e-16         ub=7.5080710e-19
+ wub=-6.5309530e-25        uc=-7.8596050e-11         wuc=-7.9500960e-17
+ rdsw=5.3000000e02         prwb=0.00                 prwg=0.00
+ wr=1.0000000              u0=1.0990191e-02+du0p     pu0=0+dpu0p
+ lu0=0+dlu0p               wu0=-1.2494747e-09+dwu0p  a0=1.0509492
+ wa0=-4.7871910e-08        keta=2.6001440e-02        wketa=6.3012270e-09
+ a1=0.00                   a2=0.4000000              ags=2.0000000e-02
+ b0=0.00                   b1=0.00                   voff=-0.1274889+dvoffp
+ pvoff=0+dpvoffp           lvoff=0+dlvoffp           wvoff=-1.0305298e-09+dwvoffp
+ nfactor=1.0000000+dnfactorp                         pnfactor=0+dpnfactorp
+ wnfactor=0+dwnfactorp     lnfactor=0+dlnfactorp     cit=-1.0000000e-04
+ cdsc=0.00                 cdscb=0.00                cdscd=0.00
+ eta0=5.0000000e-05+deta0p peta0=0+dpeta0p           weta0=0+dweta0p
+ leta0=0+dleta0p           etab=-5.0000000e-05       dsub=0.00
+ pclm=0.6000001            pdiblc1=1.0000000e-06     pdiblc2=1.0000004e-03
+ pdiblcb=1.0000000e-02     drout=0.00                pscbe1=1.9999997e08
+ pscbe2=5.0000000e-07      pvag=0.00                 delta=1.0000000e-02
+ alpha0=0.00               alpha1=6.8730453846       beta0=22.67827
+ kt1=-0.2319530            wkt1=8.2282740e-09        kt2=-2.4488758e-02
+ wkt2=1.4868883e-09        at=1.0000000e04           ute=-0.8394966
+ wute=1.0600407e-07        ua1=1.2240000e-09         ub1=-1.3998005e-18
+ wub1=6.9097150e-26        uc1=-7.6331580e-12        wuc1=3.0354498e-17
+ kt1l=0.00                 prt=0                     cj=cjp
+ pb=0.895226               mj=0.4476                 cjsw=cjswp
+ pbsw=0.895226             mjsw=0.3683619            cjswg=cjswgp
+ pbswg=0.895226            mjswg=0.3683619           cgdo=cgop
+ cgso=cgop                 tcj=0.0009739001          tcjsw=0.0004130718
+ tcjswg=0.0004130718       tpb=0.001572025           tpbsw=0.001572025
+ tpbswg=0.001572025        js=2.50e-07               jsw=1.2e-12
+ n=1                       xti=3                     capmod=3
+ nqsmod=0                  xpart=1                   cf=0
+ tlev=1                    tlevc=1                   dlc=2e-9
+ llc=-0.039                noimod=2                  ef=1.064
+ noia=9.5e+18              noib=1.0e5                noic=1.4e-12
+ em=3.0e+07                minr=1e-60                imax=0.01
+ imelt=0.01

     6: type=p
+ lmin=1.200e-06-dxlp-dlmis lmax=1.000e-05-dxlp-dlmis wmin=1.2000e-06-dxwp-dwmis
+ wmax=1.0000e-05-dxwp-dwmis                          tnom=25.0
+ version=3.24              tox=toxp+toxmis           toxm=4.08e-09
+ xj=1.7000001e-07          nch=3.9000000e17          lln=-1
+ lwn=1.0000000             wln=1.0000000             wwn=1.0000000
+ lint=1.4999999e-08        ll=0.00                   lw=0.00
+ lwl=0.00                  wint=5.0000000e-09        wl=0.00
+ ww=0.00                   wwl=0.00                  mobmod=1
+ binunit=2                 xl=-0.02e-6+dxlp+dlmis    xw=0.0+dxwp+dwmis
+ dwg=0.00                  dwb=0.00                  ldif=9.00e-08
+ hdif=hdifp                rsh=rshp                  rd=0
+ rs=0                      vth0=-0.4373293+dvthp+vthmis
+ lvth0=-2.4279869e-08+dlvthp                         wvth0=1.3406786e-08+dwvthp
+ pvth0=-5.3364720e-15+dpvthp                         k1=0.5344580
+ lk1=1.8184398e-08         wk1=1.1855070e-08         pk1=5.9862430e-15
+ k2=3.6157890e-02+dk2p     lk2=-5.2806350e-09+dlk2p  wk2=-5.7327760e-09
+ pk2=-2.0633070e-15        k3=0.00                   dvt0=0.00
+ dvt1=0.00                 dvt2=0.00                 dvt0w=0.00
+ dvt1w=0.00                dvt2w=0.00                nlx=0.00
+ w0=0.00                   k3b=0.00                  vsat=1.5130680e05+dvsatp
+ wvsat=0+dwvsatp           lvsat=-1.3002842e-02      ua=8.4528650e-10
+ lua=-3.9356080e-16        wua=1.7227619e-16         pua=3.1465633e-23
+ ub=7.0840050e-19          lub=4.2194590e-25         wub=-6.8132500e-25
+ pub=2.8088595e-31         uc=-8.0493860e-11         luc=1.8883157e-17
+ wuc=-8.0495330e-17        puc=9.8941000e-24         rdsw=5.3000000e02
+ prwb=0.00                 prwg=0.00                 wr=1.0000000
+ u0=1.1121400e-02+du0p     lu0=-1.3055237e-09+dlu0p  wu0=-1.2610760e-09+dwu0p
+ pu0=1.1543239e-16+dpu0p   a0=1.0440365              la0=6.8781320e-08
+ wa0=-5.4598760e-08        pa0=6.6932220e-14         keta=2.6128704e-02
+ lketa=-1.2662711e-09      wketa=7.0843590e-09       pketa=-7.7921670e-15
+ a1=0.00                   a2=0.4000000              ags=2.0000000e-02
+ b0=0.00                   b1=0.00                   voff=-0.1273414+dvoffp
+ lvoff=-1.4683624e-09+dlvoffp                        wvoff=-5.8798940e-10+dwvoffp
+ pvoff=-4.4032780e-15+dpvoffp                        nfactor=1.0000000+dnfactorp
+ pnfactor=0+dpnfactorp     wnfactor=0+dwnfactorp     lnfactor=0+dlnfactorp
+ cit=-1.0000000e-04        cdsc=0.00                 cdscb=0.00
+ cdscd=0.00                eta0=5.0000000e-05+deta0p peta0=0+dpeta0p
+ weta0=0+dweta0p           leta0=0+dleta0p           etab=-5.0000000e-05
+ dsub=0.00                 pclm=0.5738637            lpclm=2.6005682e-07
+ pdiblc1=1.0000000e-06     pdiblc2=4.7727280e-04     lpdiblc2=5.2011370e-09
+ pdiblcb=1.0000000e-02     drout=0.00                pscbe1=1.8039770e08
+ lpscbe1=1.9504262e02      pscbe2=5.0000000e-07      pvag=0.00
+ delta=1.0000000e-02       alpha0=0.00               alpha1=6.8730453846
+ beta0=22.67827            kt1=-0.2303147            lkt1=-1.6300865e-08
+ wkt1=7.2567470e-09        pkt1=9.6666970e-15        kt2=-2.4155809e-02
+ lkt2=-3.3128360e-09       wkt2=1.2456750e-09        pkt2=2.4000725e-15
+ at=1.0000000e04           ute=-0.8492097            lute=9.6644970e-08
+ wute=1.0644106e-07        pute=-4.3481010e-15       ua1=1.2240000e-09
+ ub1=-1.4052706e-18        lub1=5.4427270e-26        wub1=7.5526920e-26
+ pub1=-6.3976190e-32       uc1=-9.4700360e-12        luc1=1.8276951e-17
+ wuc1=2.7723443e-17        puc1=2.6178952e-23        kt1l=0.00
+ prt=0                     cj=cjp                    pb=0.895226
+ mj=0.4476                 cjsw=cjswp                pbsw=0.895226
+ mjsw=0.3683619            cjswg=cjswgp              pbswg=0.895226
+ mjswg=0.3683619           cgdo=cgop                 cgso=cgop
+ tcj=0.0009739001          tcjsw=0.0004130718        tcjswg=0.0004130718
+ tpb=0.001572025           tpbsw=0.001572025         tpbswg=0.001572025
+ js=2.50e-07               jsw=1.2e-12               n=1
+ xti=3                     capmod=3                  nqsmod=0
+ xpart=1                   cf=0                      tlev=1
+ tlevc=1                   dlc=2e-9                  llc=-0.039
+ noimod=2                  ef=1.064                  noia=9.5e+18
+ noib=1.0e5                noic=1.4e-12              em=3.0e+07
+ minr=1e-60                imax=0.01                 imelt=0.01

     7: type=p
+ lmin=5.000e-07-dxlp-dlmis lmax=1.200e-06-dxlp-dlmis wmin=1.2000e-06-dxwp-dwmis
+ wmax=1.0000e-05-dxwp-dwmis                          tnom=25.0
+ version=3.24              tox=toxp+toxmis           toxm=4.08e-09
+ xj=1.7000001e-07          nch=3.9000000e17          lln=-1
+ lwn=1.0000000             wln=1.0000000             wwn=1.0000000
+ lint=1.4999999e-08        ll=0.00                   lw=0.00
+ lwl=0.00                  wint=5.0000000e-09        wl=0.00
+ ww=0.00                   wwl=0.00                  mobmod=1
+ binunit=2                 xl=-0.02e-6+dxlp+dlmis    xw=0.0+dxwp+dwmis
+ dwg=0.00                  dwb=0.00                  ldif=9.00e-08
+ hdif=hdifp                rsh=rshp                  rd=0
+ rs=0                      vth0=-0.4527619+dvthp+vthmis
+ lvth0=-6.5323870e-09+dlvthp                         wvth0=1.0130710e-08+dwvthp
+ pvth0=-1.5689828e-15+dpvthp                         k1=0.5429910
+ lk1=8.3714530e-09         wk1=-2.4271484e-08        pk1=4.7531780e-14
+ k2=3.4362420e-02+dk2p     lk2=-3.2158540e-09+dlk2p  wk2=5.3860310e-09
+ pk2=-1.4849934e-14        k3=0.00                   dvt0=0.00
+ dvt1=0.00                 dvt2=0.00                 dvt0w=0.00
+ dvt1w=0.00                dvt2w=0.00                nlx=0.00
+ w0=0.00                   k3b=0.00                  vsat=1.4642853e05+dvsatp
+ wvsat=0+dwvsatp           lvsat=-7.3928330e-03      ua=4.7628350e-10
+ lua=3.0792715e-17         wua=5.0360140e-16         pua=-3.4955840e-22
+ ub=1.2463172e-18          lub=-1.9665828e-25        wub=-7.2802750e-25
+ pub=3.3459380e-31         uc=-3.1899420e-11         luc=-3.7000450e-17
+ wuc=-1.1410304e-16        puc=4.8542970e-23         rdsw=5.3000000e02
+ prwb=0.00                 prwg=0.00                 wr=1.0000000
+ u0=1.0286789e-02+du0p     lu0=-3.4572260e-10+dlu0p  wu0=-6.2143110e-10+dwu0p
+ pu0=-6.2015920e-16+dpu0p  a0=0.9932752              la0=1.2715688e-07
+ wa0=1.1247056e-07         pa0=-1.2519753e-13        keta=3.2315410e-02
+ lketa=-8.3809840e-09      wketa=-1.6265284e-09      pketa=2.2253538e-15
+ a1=0.00                   a2=0.4000000              ags=2.0000000e-02
+ b0=0.00                   b1=0.00                   voff=-0.1274479+dvoffp
+ lvoff=-1.3458795e-09+dlvoffp                        wvoff=-7.8664910e-09+dwvoffp
+ pvoff=3.9669990e-15+dpvoffp                         nfactor=1.0000000+dnfactorp
+ pnfactor=0+dpnfactorp     wnfactor=0+dwnfactorp     lnfactor=0+dlnfactorp
+ cit=-2.9301620e-04        lcit=2.2196864e-10        wcit=-1.7881040e-11
+ pcit=2.0563189e-17        cdsc=0.00                 cdscb=0.00
+ cdscd=0.00                eta0=1.7857139e-05+deta0p peta0=0+dpeta0p
+ weta0=0+dweta0p           leta0=3.6964290e-11+dleta0p
+ etab=-1.7857139e-05       letab=-3.6964290e-11      dsub=0.00
+ pclm=0.6714287            lpclm=1.4785702e-07       pdiblc1=1.0000000e-06
+ pdiblc2=1.7857144e-03     lpdiblc2=3.6964280e-09    pdiblcb=1.0000000e-02
+ drout=0.00                pscbe1=3.4999990e08       pscbe2=5.0000000e-07
+ pvag=0.00                 delta=1.0000000e-02       alpha0=0.00
+ alpha1=6.8730453846       beta0=22.67827            kt1=-0.2459144
+ lkt1=1.6387112e-09        wkt1=1.6218328e-08        pkt1=-6.3912370e-16
+ kt2=-2.7846618e-02        lkt2=9.3159460e-10        wkt2=2.9642964e-09
+ pkt2=4.2365790e-16        at=1.0000000e04           ute=-0.7951261
+ lute=3.4448810e-08        wute=8.4486070e-08        pute=2.0900147e-14
+ ua1=1.2240000e-09         ub1=-1.3967723e-18        lub1=4.4654300e-26
+ wub1=1.4015321e-25        pub1=-1.3829640e-31       uc1=-2.3838735e-11
+ luc1=3.4800940e-17        wuc1=9.4346610e-17        puc1=-5.0437680e-23
+ kt1l=0.00                 prt=0                     cj=cjp
+ pb=0.895226               mj=0.4476                 cjsw=cjswp
+ pbsw=0.895226             mjsw=0.3683619            cjswg=cjswgp
+ pbswg=0.895226            mjswg=0.3683619           cgdo=cgop
+ cgso=cgop                 tcj=0.0009739001          tcjsw=0.0004130718
+ tcjswg=0.0004130718       tpb=0.001572025           tpbsw=0.001572025
+ tpbswg=0.001572025        js=2.50e-07               jsw=1.2e-12
+ n=1                       xti=3                     capmod=3
+ nqsmod=0                  xpart=1                   cf=0
+ tlev=1                    tlevc=1                   dlc=2e-9
+ llc=-0.039                noimod=2                  ef=1.064
+ noia=9.5e+18              noib=1.0e5                noic=1.4e-12
+ em=3.0e+07                minr=1e-60                imax=0.01
+ imelt=0.01

     8: type=p
+ lmin=1.8e-007             lmax=5.000e-07-dxlp-dlmis wmin=1.2000e-06-dxwp-dwmis
+ wmax=1.0000e-05-dxwp-dwmis                          tnom=25.0
+ version=3.24              tox=toxp+toxmis           toxm=4.08e-09
+ xj=1.7000001e-07          nch=3.9000000e17          lln=-1
+ lwn=1.0000000             wln=1.0000000             wwn=1.0000000
+ lint=1.4999999e-08        ll=0.00                   lw=0.00
+ lwl=0.00                  wint=5.0000000e-09        wl=0.00
+ ww=0.00                   wwl=0.00                  mobmod=1
+ binunit=2                 xl=-0.02e-6+dxlp+dlmis    xw=0.0+dxwp+dwmis
+ dwg=0.00                  dwb=0.00                  ldif=9.00e-08
+ hdif=hdifp                rsh=rshp                  rd=0
+ rs=0                      vth0=-0.4492160+dvthp+vthmis
+ lvth0=-8.1280260e-09+dlvthp                         wvth0=9.1421640e-09+dwvthp
+ pvth0=-1.1241356e-15+dpvthp                         k1=0.5203763
+ lk1=1.8548040e-08         wk1=1.1998529e-07         pk1=-1.7383759e-14
+ k2=4.1939260e-02+dk2p     lk2=-6.6254260e-09+dlk2p  wk2=-4.4246340e-08
+ pk2=7.4846270e-15         k3=0.00                   dvt0=0.00
+ dvt1=0.00                 dvt2=0.00                 dvt0w=0.00
+ dvt1w=0.00                dvt2w=0.00                nlx=0.00
+ w0=0.00                   k3b=0.00                  vsat=1.3081252e05+dvsatp
+ wvsat=0+dwvsatp           lvsat=-3.6562710e-04      ua=9.3578630e-10
+ lua=-1.7598350e-16        wua=-6.2823680e-16        pua=1.5976873e-22
+ ub=5.0912570e-19          lub=1.3507784e-25         wub=3.0629255e-25
+ pub=-1.3085017e-31        uc=-1.5731644e-10         luc=1.9437196e-17
+ wuc=1.4561782e-17         puc=-9.3561970e-24        rdsw=5.3000000e02
+ prwb=0.00                 prwg=0.00                 wr=1.0000000
+ u0=9.7957610e-03+du0p     lu0=-1.2475933e-10+dlu0p  wu0=-2.5725782e-09+dwu0p
+ pu0=2.5785697e-16+dpu0p   a0=1.2640158              la0=5.3236360e-09
+ wa0=-4.0712480e-07        pa0=1.0862038e-13         keta=1.4996022e-02
+ lketa=-5.8725920e-10      wketa=8.7244130e-09       pketa=-2.4325694e-15
+ a1=0.00                   a2=0.4000000              ags=1.9847063e-02
+ lags=6.8821010e-11        wags=1.5278273e-09        pags=-6.8752220e-16
+ b0=0.00                   b1=0.00                   voff=-0.1308021+dvoffp
+ lvoff=1.6353495e-10+dlvoffp                         wvoff=5.3724310e-09+dwvoffp
+ pvoff=-1.9905158e-15+dpvoffp                        nfactor=1.0000000+dnfactorp
+ pnfactor=0+dpnfactorp     wnfactor=0+dwnfactorp     lnfactor=0+dlnfactorp
+ cit=-6.0918400e-05        lcit=1.1752459e-10        wcit=2.0354016e-10
+ pcit=-7.9076310e-17       cdsc=0.00                 cdscb=0.00
+ cdscd=-8.2898130e-05      lcdscd=3.7304140e-11      wcdscd=1.6464351e-11
+ pcdscd=-7.4089540e-18     eta0=-4.6875020e-04+deta0p
+ peta0=0+dpeta0p           weta0=0+dweta0p           leta0=2.5593752e-10+dleta0p
+ etab=1.1323938e-03        letab=-5.5457720e-10      wetab=-5.4801690e-10
+ petab=2.4660761e-16       dsub=0.00                 pclm=0.9107697
+ lpclm=4.0153610e-08       wpclm=-5.4322380e-09      ppclm=2.4445072e-15
+ pdiblc1=1.0000000e-06     pdiblc2=7.9878660e-03     lpdiblc2=9.0546000e-10
+ wpdiblc2=-1.9097854e-10   ppdiblc2=8.5940170e-17    pdiblcb=1.0000000e-02
+ drout=0.00                pscbe1=3.5000000e08       pscbe2=5.0000000e-07
+ pvag=0.00                 delta=1.0000000e-02       alpha0=0.00
+ alpha1=6.8730453846       beta0=22.67827            kt1=-0.2367561
+ lkt1=-2.4825255e-09       wkt1=1.8848993e-08        pkt1=-1.8229216e-15
+ kt2=-2.5532207e-02        lkt2=-1.0989117e-10       wkt2=6.6289560e-09
+ pkt2=-1.2254391e-15       at=1.0000000e04           ute=-0.7199521
+ lute=6.2052350e-10        wute=1.0915658e-07        pute=9.7984170e-15
+ ua1=1.2240000e-09         ub1=-1.3554493e-18        lub1=2.6058948e-26
+ wub1=-2.2890885e-25       pub1=2.7781507e-32        uc1=7.0516520e-11
+ luc1=-7.6589150e-18       wuc1=-3.5766990e-17       puc1=8.1134340e-24
+ kt1l=0.00                 prt=0                     cj=cjp
+ pb=0.895226               mj=0.4476                 cjsw=cjswp
+ pbsw=0.895226             mjsw=0.3683619            cjswg=cjswgp
+ pbswg=0.895226            mjswg=0.3683619           cgdo=cgop
+ cgso=cgop                 tcj=0.0009739001          tcjsw=0.0004130718
+ tcjswg=0.0004130718       tpb=0.001572025           tpbsw=0.001572025
+ tpbswg=0.001572025        js=2.50e-07               jsw=1.2e-12
+ n=1                       xti=3                     capmod=3
+ nqsmod=0                  xpart=1                   cf=0
+ tlev=1                    tlevc=1                   dlc=2e-9
+ llc=-0.039                noimod=2                  ef=1.064
+ noia=9.5e+18              noib=1.0e5                noic=1.4e-12
+ em=3.0e+07                minr=1e-60                imax=0.01
+ imelt=0.01

     9: type=p
+ lmin=1.000e-05-dxlp-dlmis lmax=20.001e-006          wmin=5.0000e-07-dxwp-dwmis
+ wmax=1.2000e-06-dxwp-dwmis                          tnom=25.0
+ version=3.24              tox=toxp+toxmis           toxm=4.08e-09
+ xj=1.7000001e-07          nch=3.9000000e17          lln=-1
+ lwn=1.0000000             wln=1.0000000             wwn=1.0000000
+ lint=1.4999999e-08        ll=0.00                   lw=0.00
+ lwl=0.00                  wint=5.0000000e-09        wl=0.00
+ ww=0.00                   wwl=0.00                  mobmod=1
+ binunit=2                 xl=-0.02e-6+dxlp+dlmis    xw=0.0+dxwp+dwmis
+ dwg=0.00                  dwb=0.00                  ldif=9.00e-08
+ hdif=hdifp                rsh=rshp                  rd=0
+ rs=0                      vth0=-0.4286388+dvthp+vthmis
+ pvth0=0+dpvthp            wvth0=-3.7506110e-10+dwvthp
+ k1=0.5449055              lvth0=0+dlvthp            wk1=2.1990281e-09
+ k2=3.3849380e-02+dk2p     lk2=0+dlk2p               wk2=-3.8245820e-09
+ k3=0.00                   dvt0=0.00                 dvt1=0.00
+ dvt2=0.00                 dvt0w=0.00                dvt1w=0.00
+ dvt2w=0.00                nlx=0.00                  w0=0.00
+ k3b=0.00                  vsat=1.4999998e05+dvsatp  wvsat=0+dwvsatp
+ ua=1.0698959e-09          wua=-1.3891575e-16        ub=3.0837888e-19
+ wub=-1.2660565e-25        uc=-1.1659398e-10         wuc=-3.4283420e-17
+ rdsw=5.3000000e02         prwb=0.00                 prwg=0.00
+ wr=1.0000000              u0=1.0132165e-02+du0p     pu0=0+dpu0p
+ lu0=0+dlu0p               wu0=-2.2842360e-10+dwu0p  a0=0.9810578
+ wa0=3.5298850e-08         keta=3.2175460e-02        wketa=-1.0458587e-09
+ a1=0.00                   a2=0.4000000              ags=2.0000000e-02
+ b0=0.00                   b1=0.00                   voff=-0.1280100+dvoffp
+ pvoff=0+dpvoffp           lvoff=0+dlvoffp           wvoff=-4.1052410e-10+dwvoffp
+ nfactor=1.0000000+dnfactorp                         pnfactor=0+dpnfactorp
+ wnfactor=0+dwnfactorp     lnfactor=0+dlnfactorp     cit=-1.0000000e-04
+ cdsc=0.00                 cdscb=0.00                cdscd=0.00
+ eta0=5.0000000e-05+deta0p peta0=0+dpeta0p           weta0=0+dweta0p
+ leta0=0+dleta0p           etab=-5.0000000e-05       dsub=0.00
+ pclm=0.6000000            pdiblc1=1.0000000e-06     pdiblc2=9.9999980e-04
+ pdiblcb=1.0000000e-02     drout=0.00                pscbe1=1.9999997e08
+ pscbe2=5.0000000e-07      pvag=0.00                 delta=1.0000000e-02
+ alpha0=0.00               alpha1=6.8730453846       beta0=22.67827
+ kt1=-0.2307052            wkt1=6.7433300e-09        kt2=-2.3348080e-02
+ wkt2=1.2948118e-10        at=1.0000000e04           ute=-0.7480742
+ wute=-2.7886795e-09       ua1=1.2240000e-09         ub1=-1.3711068e-18
+ wub1=3.4951630e-26        uc1=1.6263793e-12         wuc1=1.9335648e-17
+ kt1l=0.00                 prt=0                     cj=cjp
+ pb=0.895226               mj=0.4476                 cjsw=cjswp
+ pbsw=0.895226             mjsw=0.3683619            cjswg=cjswgp
+ pbswg=0.895226            mjswg=0.3683619           cgdo=cgop
+ cgso=cgop                 tcj=0.0009739001          tcjsw=0.0004130718
+ tcjswg=0.0004130718       tpb=0.001572025           tpbsw=0.001572025
+ tpbswg=0.001572025        js=2.50e-07               jsw=1.2e-12
+ n=1                       xti=3                     capmod=3
+ nqsmod=0                  xpart=1                   cf=0
+ tlev=1                    tlevc=1                   dlc=2e-9
+ llc=-0.039                noimod=2                  ef=1.064
+ noia=9.5e+18              noib=1.0e5                noic=1.4e-12
+ em=3.0e+07                minr=1e-60                imax=0.01
+ imelt=0.01

     10: type=p
+ lmin=1.200e-06-dxlp-dlmis lmax=1.000e-05-dxlp-dlmis wmin=5.0000e-07-dxwp-dwmis
+ wmax=1.2000e-06-dxwp-dwmis                          tnom=25.0
+ version=3.24              tox=toxp+toxmis           toxm=4.08e-09
+ xj=1.7000001e-07          nch=3.9000000e17          lln=-1
+ lwn=1.0000000             wln=1.0000000             wwn=1.0000000
+ lint=1.4999999e-08        ll=0.00                   lw=0.00
+ lwl=0.00                  wint=5.0000000e-09        wl=0.00
+ ww=0.00                   wwl=0.00                  mobmod=1
+ binunit=2                 xl=-0.02e-6+dxlp+dlmis    xw=0.0+dxwp+dwmis
+ dwg=0.00                  dwb=0.00                  ldif=9.00e-08
+ hdif=hdifp                rsh=rshp                  rd=0
+ rs=0                      vth0=-0.4245711+dvthp+vthmis
+ lvth0=-4.0472930e-08+dlvthp                         wvth0=-1.7753915e-09+dwvthp
+ pvth0=1.3933270e-14+dpvthp                          k1=0.5429414
+ lk1=1.9542425e-08         wk1=1.7598129e-09         pk1=4.3701940e-15
+ k2=3.4365640e-02+dk2p     lk2=-5.1367190e-09+dlk2p  wk2=-3.6000030e-09
+ pk2=-2.2345663e-15        k3=0.00                   dvt0=0.00
+ dvt1=0.00                 dvt2=0.00                 dvt0w=0.00
+ dvt1w=0.00                dvt2w=0.00                nlx=0.00
+ w0=0.00                   k3b=0.00                  vsat=1.5130680e05+dvsatp
+ wvsat=0+dwvsatp           lvsat=-1.3002842e-02      ua=1.1283389e-09
+ lua=-5.8150770e-16        wua=-1.6455617e-16        pua=2.5512236e-22
+ ub=1.9594849e-19          lub=1.1186816e-24         wub=-7.1507210e-26
+ pub=-5.4822940e-31        uc=-1.2405904e-10         luc=7.4277340e-17
+ wuc=-2.8652769e-17        puc=-5.6024980e-23        rdsw=5.3000000e02
+ prwb=0.00                 prwg=0.00                 wr=1.0000000
+ u0=1.0228163e-02+du0p     lu0=-9.5517820e-10+dlu0p  wu0=-1.9812424e-10+dwu0p
+ pu0=-3.0147877e-16+dpu0p  a0=0.9688198              la0=1.2176828e-07
+ wa0=3.4909120e-08         pa0=3.8777300e-15         keta=3.2820440e-02
+ lketa=-6.4175870e-09      wketa=-8.7881330e-10      pketa=-1.6621007e-15
+ a1=0.00                   a2=0.4000000              ags=2.0000000e-02
+ b0=0.00                   b1=0.00                   voff=-0.1269095+dvoffp
+ lvoff=-1.0948965e-08+dlvoffp                        wvoff=-1.1018445e-09+dwvoffp
+ pvoff=6.8786400e-15+dpvoffp                         nfactor=1.0000000+dnfactorp
+ pnfactor=0+dpnfactorp     wnfactor=0+dwnfactorp     lnfactor=0+dlnfactorp
+ cit=-1.0000000e-04        cdsc=0.00                 cdscb=0.00
+ cdscd=0.00                eta0=5.0000000e-05+deta0p peta0=0+dpeta0p
+ weta0=0+dweta0p           leta0=0+dleta0p           etab=-5.0000000e-05
+ dsub=0.00                 pclm=0.5738636            lpclm=2.6005682e-07
+ pdiblc1=1.0000000e-06     pdiblc2=4.7727220e-04     lpdiblc2=5.2011370e-09
+ pdiblcb=1.0000000e-02     drout=0.00                pscbe1=1.8039768e08
+ lpscbe1=1.9504263e02      pscbe2=5.0000000e-07      pvag=0.00
+ delta=1.0000000e-02       alpha0=0.00               alpha1=6.8730453846
+ beta0=22.67827            kt1=-0.2296747            lkt1=-1.0252924e-08
+ wkt1=6.4951250e-09        pkt1=2.4696450e-15        kt2=-2.3308404e-02
+ lkt2=-3.9477850e-10       wkt2=2.3726165e-10        pkt2=-1.0724159e-15
+ at=1.0000000e04           ute=-0.7541180            lute=6.0136590e-08
+ wute=-6.7180150e-09       pute=3.9096880e-14        ua1=1.2240000e-09
+ ub1=-1.3784619e-18        lub1=7.3183410e-26        wub1=4.3624580e-26
+ pub1=-8.6295970e-32       uc1=-1.1517035e-12        luc1=2.7641896e-17
+ wuc1=1.7824627e-17        puc1=1.5034668e-23        kt1l=0.00
+ prt=0                     cj=cjp                    pb=0.895226
+ mj=0.4476                 cjsw=cjswp                pbsw=0.895226
+ mjsw=0.3683619            cjswg=cjswgp              pbswg=0.895226
+ mjswg=0.3683619           cgdo=cgop                 cgso=cgop
+ tcj=0.0009739001          tcjsw=0.0004130718        tcjswg=0.0004130718
+ tpb=0.001572025           tpbsw=0.001572025         tpbswg=0.001572025
+ js=2.50e-07               jsw=1.2e-12               n=1
+ xti=3                     capmod=3                  nqsmod=0
+ xpart=1                   cf=0                      tlev=1
+ tlevc=1                   dlc=2e-9                  llc=-0.039
+ noimod=2                  ef=1.064                  noia=9.5e+18
+ noib=1.0e5                noic=1.4e-12              em=3.0e+07
+ minr=1e-60                imax=0.01                 imelt=0.01

     11: type=p
+ lmin=5.000e-07-dxlp-dlmis lmax=1.200e-06-dxlp-dlmis wmin=5.0000e-07-dxwp-dwmis
+ wmax=1.2000e-06-dxwp-dwmis                          tnom=25.0
+ version=3.24              tox=toxp+toxmis           toxm=4.08e-09
+ xj=1.7000001e-07          nch=3.9000000e17          lln=-1
+ lwn=1.0000000             wln=1.0000000             wwn=1.0000000
+ lint=1.4999999e-08        ll=0.00                   lw=0.00
+ lwl=0.00                  wint=5.0000000e-09        wl=0.00
+ ww=0.00                   wwl=0.00                  mobmod=1
+ binunit=2                 xl=-0.02e-6+dxlp+dlmis    xw=0.0+dxwp+dwmis
+ dwg=0.00                  dwb=0.00                  ldif=9.00e-08
+ hdif=hdifp                rsh=rshp                  rd=0
+ rs=0                      vth0=-0.4566670+dvthp+vthmis
+ lvth0=-3.5627020e-09+dlvthp                         wvth0=1.4777807e-08+dwvthp
+ pvth0=-5.1029080e-15+dpvthp                         k1=0.4715038
+ lk1=1.0169572e-07         wk1=6.0798340e-08         pk1=-6.3524100e-14
+ k2=5.9786750e-02+dk2p     lk2=-3.4371000e-08+dlk2p  wk2=-2.4868919e-08
+ pk2=2.2224691e-14         k3=0.00                   dvt0=0.00
+ dvt1=0.00                 dvt2=0.00                 dvt0w=0.00
+ dvt1w=0.00                dvt2w=0.00                nlx=0.00
+ w0=0.00                   k3b=0.00                  vsat=1.4642856e05+dvsatp
+ wvsat=0+dwvsatp           lvsat=-7.3928550e-03      ua=1.0361150e-09
+ lua=-4.7545010e-16        wua=-1.6259810e-16        pua=2.5287059e-22
+ ub=1.0523674e-18          lub=1.3379980e-25         wub=-4.9722730e-25
+ pub=-5.8651310e-32        uc=-7.2051170e-11         luc=1.4468274e-17
+ wuc=-6.6322470e-17        puc=-1.2704817e-23        rdsw=5.3000000e02
+ prwb=0.00                 prwg=0.00                 wr=1.0000000
+ u0=1.0727104e-02+du0p     lu0=-1.5289595e-09+dlu0p  wu0=-1.1454039e-09+dwu0p
+ pu0=7.8789280e-16+dpu0p   a0=1.1936638              la0=-1.3680231e-07
+ wa0=-1.2599192e-07        pa0=1.8891395e-13         keta=3.5842650e-02
+ lketa=-9.8931220e-09      wketa=-5.8239420e-09      pketa=4.0247990e-15
+ a1=0.00                   a2=0.4000000              ags=2.0000000e-02
+ b0=0.00                   b1=0.00                   voff=-0.1409845+dvoffp
+ lvoff=5.2372110e-09+dlvoffp                         wvoff=8.2420830e-09+dwvoffp
+ pvoff=-3.8668790e-15+dpvoffp                        nfactor=1.0000000+dnfactorp
+ pnfactor=0+dpnfactorp     wnfactor=0+dwnfactorp     lnfactor=0+dlnfactorp
+ cit=-3.1597191e-04        lcit=2.4836766e-10        wcit=9.4362210e-12
+ pcit=-1.0851648e-17       cdsc=0.00                 cdscb=0.00
+ cdscd=0.00                eta0=1.7857154e-05+deta0p peta0=0+dpeta0p
+ weta0=0+dweta0p           leta0=3.6964260e-11+dleta0p
+ etab=-1.7857154e-05       letab=-3.6964260e-11      dsub=0.00
+ pclm=0.6714286            lpclm=1.4785714e-07       pdiblc1=1.0000000e-06
+ pdiblc2=1.7857137e-03     lpdiblc2=3.6964290e-09    pdiblcb=1.0000000e-02
+ drout=0.00                pscbe1=3.4999990e08       pscbe2=5.0000000e-07
+ pvag=0.00                 delta=1.0000000e-02       alpha0=0.00
+ alpha1=6.8730453846       beta0=22.67827            kt1=-0.2439705
+ lkt1=6.1872760e-09        wkt1=1.3905176e-08        pkt1=-6.0519150e-15
+ kt2=-2.5852976e-02        lkt2=2.5314804e-09        wkt2=5.9186180e-10
+ pkt2=-1.4802061e-15       at=1.0000000e04           ute=-0.7903757
+ lute=1.0183292e-07        wute=7.8833130e-08        pute=-5.9286950e-14
+ ua1=1.2240000e-09         ub1=-1.2162624e-18        lub1=-1.1334610e-25
+ wub1=-7.4653720e-26       pub1=4.9724100e-32        uc1=4.2107970e-11
+ luc1=-2.2106738e-17       wuc1=1.5870021e-17        puc1=1.7282469e-23
+ kt1l=0.00                 prt=0                     cj=cjp
+ pb=0.895226               mj=0.4476                 cjsw=cjswp
+ pbsw=0.895226             mjsw=0.3683619            cjswg=cjswgp
+ pbswg=0.895226            mjswg=0.3683619           cgdo=cgop
+ cgso=cgop                 tcj=0.0009739001          tcjsw=0.0004130718
+ tcjswg=0.0004130718       tpb=0.001572025           tpbsw=0.001572025
+ tpbswg=0.001572025        js=2.50e-07               jsw=1.2e-12
+ n=1                       xti=3                     capmod=3
+ nqsmod=0                  xpart=1                   cf=0
+ tlev=1                    tlevc=1                   dlc=2e-9
+ llc=-0.039                noimod=2                  ef=1.064
+ noia=9.5e+18              noib=1.0e5                noic=1.4e-12
+ em=3.0e+07                minr=1e-60                imax=0.01
+ imelt=0.01

     12: type=p
+ lmin=1.8e-007             lmax=5.000e-07-dxlp-dlmis wmin=5.0000e-07-dxwp-dwmis
+ wmax=1.2000e-06-dxwp-dwmis                          tnom=25.0
+ version=3.24              tox=toxp+toxmis           toxm=4.08e-09
+ xj=1.7000001e-07          nch=3.9000000e17          lln=-1
+ lwn=1.0000000             wln=1.0000000             wwn=1.0000000
+ lint=1.4999999e-08        ll=0.00                   lw=0.00
+ lwl=0.00                  wint=5.0000000e-09        wl=0.00
+ ww=0.00                   wwl=0.00                  mobmod=1
+ binunit=2                 xl=-0.02e-6+dxlp+dlmis    xw=0.0+dxwp+dwmis
+ dwg=0.00                  dwb=0.00                  ldif=9.00e-08
+ hdif=hdifp                rsh=rshp                  rd=0
+ rs=0                      vth0=-0.4463558+dvthp+vthmis
+ lvth0=-8.2027190e-09+dlvthp                         wvth0=5.7385650e-09+dwvthp
+ pvth0=-1.0352502e-15+dpvthp                         k1=0.7171482
+ lk1=-8.8442780e-09        wk1=-1.1417325e-07        pk1=1.5213101e-14
+ k2=-2.7492139e-02+dk2p    lk2=4.9044990e-09+dlk2p   wk2=3.8377030e-08
+ pk2=-6.2359860e-15        k3=0.00                   dvt0=0.00
+ dvt1=0.00                 dvt2=0.00                 dvt0w=0.00
+ dvt1w=0.00                dvt2w=0.00                nlx=0.00
+ w0=0.00                   k3b=0.00                  vsat=1.3081246e05+dvsatp
+ wvsat=0+dwvsatp           lvsat=-3.6561420e-04      ua=-7.3364270e-11
+ lua=2.3815556e-17         wua=5.7265230e-16         pua=-7.7992140e-23
+ ub=1.4258127e-18          lub=-3.4250630e-26        wub=-7.8456510e-25
+ pub=7.0650720e-32         uc=-5.9462960e-11         luc=8.8035780e-18
+ wuc=-1.0188386e-16        puc=3.2978070e-24         rdsw=5.3000000e02
+ prwb=0.00                 prwg=0.00                 wr=1.0000000
+ u0=6.8583350e-03+du0p     lu0=2.1198607e-10+dlu0p   wu0=9.2295840e-10+dwu0p
+ pu0=-1.4287007e-16+dpu0p  a0=0.5166956              la0=1.6783336e-07
+ wa0=4.8218620e-07         pa0=-8.4766190e-14        keta=1.7911140e-02
+ lketa=-1.8239428e-09      wketa=5.2554230e-09       pketa=-9.6091580e-16
+ a1=0.00                   a2=0.4000000              ags=1.0547621e-02
+ lags=4.2535690e-09        wags=1.2594167e-08        pags=-5.6673740e-15
+ b0=0.00                   b1=0.00                   voff=-0.1286711+dvoffp
+ lvoff=-3.0382863e-10+dlvoffp                        wvoff=2.8364715e-09+dwvoffp
+ pvoff=-1.4343533e-15+dpvoffp                        nfactor=1.0000000+dnfactorp
+ pnfactor=0+dpnfactorp     wnfactor=0+dwnfactorp     lnfactor=0+dlnfactorp
+ cit=1.2746976e-04         lcit=4.8818930e-11        wcit=-2.0641719e-11
+ pcit=2.6834248e-18        cdsc=0.00                 cdscb=0.00
+ cdscd=-5.2000010e-05      lcdscd=2.3400004e-11      wcdscd=-2.0304376e-11
+ pcdscd=9.1369700e-18      eta0=-4.6875000e-04+deta0p
+ peta0=0+dpeta0p           weta0=0+dweta0p           leta0=2.5593747e-10+dleta0p
+ etab=6.7187530e-04        letab=-3.4734380e-10      dsub=0.00
+ pclm=0.8585470            lpclm=6.3653840e-08       wpclm=5.6712850e-08
+ ppclm=-2.5520774e-14      pdiblc1=1.0000000e-06     pdiblc2=9.1502970e-03
+ lpdiblc2=3.8236610e-10    wpdiblc2=-1.5742713e-09   ppdiblc2=7.0842200e-16
+ pdiblcb=1.0000000e-02     drout=0.00                pscbe1=3.5000000e08
+ pscbe2=5.0000000e-07      pvag=0.00                 delta=1.0000000e-02
+ alpha0=0.00               alpha1=6.8730453846       beta0=22.67827
+ kt1=-0.2211471            lkt1=-4.0832670e-09       wkt1=2.7434011e-10
+ pkt1=8.1960910e-17        kt2=-1.4824204e-02        lkt2=-2.4314675e-09
+ wkt2=-6.1135670e-09       pkt2=1.5372367e-15        at=1.0000000e04
+ ute=-0.5812994            lute=7.7485560e-09        wute=-5.5840220e-08
+ pute=1.3160581e-15        ua1=1.2240000e-09         ub1=-1.6175756e-18
+ lub1=6.7244840e-26        wub1=8.3021400e-26        pub1=-2.1229706e-32
+ uc1=-2.2818641e-11        luc1=7.1102340e-18        wuc1=7.5301860e-17
+ puc1=-9.4618550e-24       kt1l=0.00                 prt=0
+ cj=cjp                    pb=0.895226               mj=0.4476
+ cjsw=cjswp                pbsw=0.895226             mjsw=0.3683619
+ cjswg=cjswgp              pbswg=0.895226            mjswg=0.3683619
+ cgdo=cgop                 cgso=cgop                 tcj=0.0009739001
+ tcjsw=0.0004130718        tcjswg=0.0004130718       tpb=0.001572025
+ tpbsw=0.001572025         tpbswg=0.001572025        js=2.50e-07
+ jsw=1.2e-12               n=1                       xti=3
+ capmod=3                  nqsmod=0                  xpart=1
+ cf=0                      tlev=1                    tlevc=1
+ dlc=2e-9                  llc=-0.039                noimod=2
+ ef=1.064                  noia=9.5e+18              noib=1.0e5
+ noic=1.4e-12              em=3.0e+07                minr=1e-60
+ imax=0.01                 imelt=0.01

     13: type=p
+ lmin=1.000e-05-dxlp-dlmis lmax=20.001e-006          wmin=2.2e-007
+ wmax=5.0000e-07-dxwp-dwmis                          tnom=25.0
+ version=3.24              tox=toxp+toxmis           toxm=4.08e-09
+ xj=1.7000001e-07          nch=3.9000000e17          lln=-1
+ lwn=1.0000000             wln=1.0000000             wwn=1.0000000
+ lint=1.4999999e-08        ll=0.00                   lw=0.00
+ lwl=0.00                  wint=5.0000000e-09        wl=0.00
+ ww=0.00                   wwl=0.00                  mobmod=1
+ binunit=2                 xl=-0.02e-6+dxlp+dlmis    xw=0.0+dxwp+dwmis
+ dwg=0.00                  dwb=0.00                  ldif=9.00e-08
+ hdif=hdifp                rsh=rshp                  rd=0
+ rs=0                      vth0=-0.4484667+dvthp+vthmis
+ pvth0=0+dpvthp            wvth0=9.3406130e-09+dwvthp
+ k1=0.5421249              lvth0=0+dlvthp            wk1=3.5615110e-09
+ k2=3.5676420e-02+dk2p     lk2=0+dlk2p               wk2=-4.7198290e-09
+ k3=0.00                   dvt0=0.00                 dvt1=0.00
+ dvt2=0.00                 dvt0w=0.00                dvt1w=0.00
+ dvt2w=0.00                nlx=0.00                  w0=0.00
+ k3b=0.00                  vsat=1.4999998e05+dvsatp  wvsat=0+dwvsatp
+ ua=1.2584637e-09          wua=-2.3131395e-16        ub=4.9999990e-20
+ uc=-1.6065008e-10         wuc=-1.2695932e-17        rdsw=5.3000000e02
+ prwb=0.00                 prwg=0.00                 wr=1.0000000
+ u0=9.7483340e-03+du0p     pu0=0+dpu0p               lu0=0+dlu0p
+ wu0=-4.0346860e-11+dwu0p  a0=0.8704194              wa0=8.9511660e-08
+ keta=4.3109410e-02        wketa=-6.4034920e-09      a1=0.00
+ a2=0.4000000              ags=2.0000000e-02         b0=0.00
+ b1=0.00                   voff=-0.1261533+dvoffp    pvoff=0+dpvoffp
+ lvoff=0+dlvoffp           wvoff=-1.3202980e-09+dwvoffp
+ nfactor=1.0000000+dnfactorp                         pnfactor=0+dpnfactorp
+ wnfactor=0+dwnfactorp     lnfactor=0+dlnfactorp     cit=-1.0000000e-04
+ cdsc=0.00                 cdscb=0.00                cdscd=0.00
+ eta0=5.0000000e-05+deta0p peta0=0+dpeta0p           weta0=0+dweta0p
+ leta0=0+dleta0p           etab=-5.0000000e-05       dsub=0.00
+ pclm=0.5999999            pdiblc1=1.0000000e-06     pdiblc2=1.0000000e-03
+ pdiblcb=1.0000000e-02     drout=0.00                pscbe1=1.9999997e08
+ pscbe2=5.0000000e-07      pvag=0.00                 delta=1.0000000e-02
+ alpha0=0.00               alpha1=6.8730453846       beta0=22.67827
+ kt1=-0.2247607            wkt1=3.8305540e-09        kt2=-2.7069092e-02
+ wkt2=1.9527771e-09        at=1.0000000e04           ute=-0.7678431
+ wute=6.8981090e-09        ua1=1.2240000e-09         ub1=-1.3041941e-18
+ wub1=2.1644123e-27        uc1=6.6651710e-11         wuc1=-1.2526765e-17
+ kt1l=0.00                 prt=0                     cj=cjp
+ pb=0.895226               mj=0.4476                 cjsw=cjswp
+ pbsw=0.895226             mjsw=0.3683619            cjswg=cjswgp
+ pbswg=0.895226            mjswg=0.3683619           cgdo=cgop
+ cgso=cgop                 tcj=0.0009739001          tcjsw=0.0004130718
+ tcjswg=0.0004130718       tpb=0.001572025           tpbsw=0.001572025
+ tpbswg=0.001572025        js=2.50e-07               jsw=1.2e-12
+ n=1                       xti=3                     capmod=3
+ nqsmod=0                  xpart=1                   cf=0
+ tlev=1                    tlevc=1                   dlc=2e-9
+ llc=-0.039                noimod=2                  ef=1.064
+ noia=9.5e+18              noib=1.0e5                noic=1.4e-12
+ em=3.0e+07                minr=1e-60                imax=0.01
+ imelt=0.01

     14: type=p
+ lmin=1.200e-06-dxlp-dlmis lmax=1.000e-05-dxlp-dlmis wmin=2.2e-007
+ wmax=5.0000e-07-dxwp-dwmis                          tnom=25.0
+ version=3.24              tox=toxp+toxmis           toxm=4.08e-09
+ xj=1.7000001e-07          nch=3.9000000e17          lln=-1
+ lwn=1.0000000             wln=1.0000000             wwn=1.0000000
+ lint=1.4999999e-08        ll=0.00                   lw=0.00
+ lwl=0.00                  wint=5.0000000e-09        wl=0.00
+ ww=0.00                   wwl=0.00                  mobmod=1
+ binunit=2                 xl=-0.02e-6+dxlp+dlmis    xw=0.0+dxwp+dwmis
+ dwg=0.00                  dwb=0.00                  ldif=9.00e-08
+ hdif=hdifp                rsh=rshp                  rd=0
+ rs=0                      vth0=-0.4480035+dvthp+vthmis
+ lvth0=-4.6083350e-09+dlvthp                         wvth0=9.7064800e-09+dwvthp
+ pvth0=-3.6403820e-15+dpvthp                         k1=0.5470301
+ lk1=-4.8806700e-08        wk1=-2.4364055e-10        pk1=3.7861260e-14
+ k2=3.3334490e-02+dk2p     lk2=2.3302198e-08+dlk2p   wk2=-3.0947396e-09
+ pk2=-1.6169635e-14        k3=0.00                   dvt0=0.00
+ dvt1=0.00                 dvt2=0.00                 dvt0w=0.00
+ dvt1w=0.00                dvt2w=0.00                nlx=0.00
+ w0=0.00                   k3b=0.00                  vsat=1.5130680e05+dvsatp
+ wvsat=0+dwvsatp           lvsat=-1.3002842e-02      ua=1.2617201e-09
+ lua=-3.2401100e-17        wua=-2.2991296e-16        pua=-1.3939852e-23
+ ub=5.0039600e-20          lub=-3.9414270e-28        wub=-1.1822094e-29
+ pub=1.1764949e-34         uc=-1.5373321e-10         luc=-6.8822930e-17
+ wuc=-1.4112429e-17        puc=1.4094153e-23         rdsw=5.3000000e02
+ prwb=0.00                 prwg=0.00                 wr=1.0000000
+ u0=9.7784860e-03+du0p     lu0=-3.0000519e-10+dlu0p  wu0=2.2217313e-11+dwu0p
+ pu0=-6.2251350e-16+dpu0p  a0=0.8193527              la0=5.0811370e-07
+ wa0=1.0814799e-07         pa0=-1.8543150e-13        keta=4.7694810e-02
+ lketa=-4.5624760e-08      wketa=-8.1672530e-09      pketa=1.7549415e-14
+ a1=0.00                   a2=0.4000000              ags=2.0000000e-02
+ b0=0.00                   b1=0.00                   voff=-0.1259132+dvoffp
+ lvoff=-2.3886029e-09+dlvoffp                        wvoff=-1.5900530e-09+dwvoffp
+ pvoff=2.6840621e-15+dpvoffp                         nfactor=1.0000000+dnfactorp
+ pnfactor=0+dpnfactorp     wnfactor=0+dwnfactorp     lnfactor=0+dlnfactorp
+ cit=-1.0000000e-04        cdsc=0.00                 cdscb=0.00
+ cdscd=0.00                eta0=5.0000000e-05+deta0p peta0=0+dpeta0p
+ weta0=0+dweta0p           leta0=0+dleta0p           etab=-5.0000000e-05
+ dsub=0.00                 pclm=0.5738635            lpclm=2.6005691e-07
+ pdiblc1=1.0000000e-06     pdiblc2=4.7727290e-04     lpdiblc2=5.2011360e-09
+ pdiblcb=1.0000000e-02     drout=0.00                pscbe1=1.8039770e08
+ lpscbe1=1.9504262e02      pscbe2=5.0000000e-07      pvag=0.00
+ delta=1.0000000e-02       alpha0=0.00               alpha1=6.8730453846
+ beta0=22.67827            kt1=-0.2237138            lkt1=-1.0417262e-08
+ wkt1=3.5742560e-09        pkt1=2.5501714e-15        kt2=-2.6908273e-02
+ lkt2=-1.6001408e-09       wkt2=2.0011981e-09        pkt2=-4.8178840e-16
+ at=1.0000000e04           ute=-0.7908860            lute=2.2927659e-07
+ wute=1.1298283e-08        pute=-4.3781730e-14       ua1=1.2240000e-09
+ ub1=-1.2832692e-18        lub1=-2.0820251e-25       wub1=-3.0198158e-27
+ pub1=5.1583110e-32        uc1=5.6680550e-11         luc1=9.9213070e-17
+ wuc1=-1.0513175e-17       puc1=-2.0035212e-23       kt1l=0.00
+ prt=0                     cj=cjp                    pb=0.895226
+ mj=0.4476                 cjsw=cjswp                pbsw=0.895226
+ mjsw=0.3683619            cjswg=cjswgp              pbswg=0.895226
+ mjswg=0.3683619           cgdo=cgop                 cgso=cgop
+ tcj=0.0009739001          tcjsw=0.0004130718        tcjswg=0.0004130718
+ tpb=0.001572025           tpbsw=0.001572025         tpbswg=0.001572025
+ js=2.50e-07               jsw=1.2e-12               n=1
+ xti=3                     capmod=3                  nqsmod=0
+ xpart=1                   cf=0                      tlev=1
+ tlevc=1                   dlc=2e-9                  llc=-0.039
+ noimod=2                  ef=1.064                  noia=9.5e+18
+ noib=1.0e5                noic=1.4e-12              em=3.0e+07
+ minr=1e-60                imax=0.01                 imelt=0.01

     15: type=p
+ lmin=5.000e-07-dxlp-dlmis lmax=1.200e-06-dxlp-dlmis wmin=2.2e-007
+ wmax=5.0000e-07-dxwp-dwmis                          tnom=25.0
+ version=3.24              tox=toxp+toxmis           toxm=4.08e-09
+ xj=1.7000001e-07          nch=3.9000000e17          lln=-1
+ lwn=1.0000000             wln=1.0000000             wwn=1.0000000
+ lint=1.4999999e-08        ll=0.00                   lw=0.00
+ lwl=0.00                  wint=5.0000000e-09        wl=0.00
+ ww=0.00                   wwl=0.00                  mobmod=1
+ binunit=2                 xl=-0.02e-6+dxlp+dlmis    xw=0.0+dxwp+dwmis
+ dwg=0.00                  dwb=0.00                  ldif=9.00e-08
+ hdif=hdifp                rsh=rshp                  rd=0
+ rs=0                      vth0=-0.4385042+dvthp+vthmis
+ lvth0=-1.5532533e-08+dlvthp                         wvth0=5.8780540e-09+dwvthp
+ pvth0=7.6230860e-16+dpvthp                          k1=0.5102190
+ lk1=-6.4738780e-09        wk1=4.1827890e-08         pk1=-1.0521005e-14
+ k2=5.4106280e-02+dk2p     lk2=-5.8536280e-10+dlk2p  wk2=-2.2085489e-08
+ pk2=5.6697290e-15         k3=0.00                   dvt0=0.00
+ dvt1=0.00                 dvt2=0.00                 dvt0w=0.00
+ dvt1w=0.00                dvt2w=0.00                nlx=0.00
+ w0=0.00                   k3b=0.00                  vsat=1.4642852e05+dvsatp
+ wvsat=0+dwvsatp           lvsat=-7.3928160e-03      ua=1.0922192e-09
+ lua=1.6252487e-16         wua=-1.9008923e-16        pua=-5.9737160e-23
+ ub=2.0536515e-20          lub=3.3534410e-26         wub=8.3698470e-27
+ pub=-9.5212690e-33        uc=-2.1836380e-10         luc=5.5022750e-18
+ wuc=5.3707260e-18         puc=-8.3114780e-24        rdsw=5.3000000e02
+ prwb=0.00                 prwg=0.00                 wr=1.0000000
+ u0=9.2032870e-03+du0p     lu0=3.6147370e-10+dlu0p   wu0=-3.9873410e-10+dwu0p
+ pu0=-1.3841940e-16+dpu0p  a0=1.1508681              la0=1.2687106e-07
+ wa0=-1.0502199e-07        pa0=5.9713990e-14         keta=4.4842080e-04
+ lketa=8.7085910e-09       wketa=1.1519229e-08       pketa=-5.0900410e-15
+ a1=0.00                   a2=0.4000000              ags=2.0000000e-02
+ b0=0.00                   b1=0.00                   voff=-0.1186655+dvoffp
+ lvoff=-1.0723419e-08+dlvoffp                        wvoff=-2.6941984e-09+dwvoffp
+ pvoff=3.9538300e-15+dpvoffp                         nfactor=1.0000000+dnfactorp
+ pnfactor=0+dpnfactorp     wnfactor=0+dwnfactorp     lnfactor=0+dlnfactorp
+ cit=-2.9671428e-04        lcit=2.2622144e-10        cdsc=0.00
+ cdscb=0.00                cdscd=0.00                eta0=1.7857146e-05+deta0p
+ peta0=0+dpeta0p           weta0=0+dweta0p           leta0=3.6964280e-11+dleta0p
+ etab=-1.7857146e-05       letab=-3.6964280e-11      dsub=0.00
+ pclm=0.6714286            lpclm=1.4785714e-07       pdiblc1=1.0000000e-06
+ pdiblc2=1.7857139e-03     lpdiblc2=3.6964290e-09    pdiblcb=1.0000000e-02
+ drout=0.00                pscbe1=3.4999990e08       pscbe2=5.0000000e-07
+ pvag=0.00                 delta=1.0000000e-02       alpha0=0.00
+ alpha1=6.8730453846       beta0=22.67827            kt1=-0.2426738
+ lkt1=1.1386779e-08        wkt1=1.3269771e-08        pkt1=-8.5996710e-15
+ kt2=-2.7530843e-02        lkt2=-8.8418580e-10       wkt2=1.4140165e-09
+ pkt2=1.9347028e-16        at=1.0000000e04           ute=-0.5904401
+ lute=-1.2362289e-09       wute=-1.9135335e-08       pute=-8.7830670e-15
+ ua1=1.2240000e-09         ub1=-1.4562286e-18        lub1=-9.2991590e-27
+ wub1=4.2929760e-26        pub1=-1.2589071e-33       uc1=1.3909653e-10
+ luc1=4.4346890e-18        wuc1=-3.1654370e-17       puc1=4.2771700e-24
+ kt1l=0.00                 prt=0                     cj=cjp
+ pb=0.895226               mj=0.4476                 cjsw=cjswp
+ pbsw=0.895226             mjsw=0.3683619            cjswg=cjswgp
+ pbswg=0.895226            mjswg=0.3683619           cgdo=cgop
+ cgso=cgop                 tcj=0.0009739001          tcjsw=0.0004130718
+ tcjswg=0.0004130718       tpb=0.001572025           tpbsw=0.001572025
+ tpbswg=0.001572025        js=2.50e-07               jsw=1.2e-12
+ n=1                       xti=3                     capmod=3
+ nqsmod=0                  xpart=1                   cf=0
+ tlev=1                    tlevc=1                   dlc=2e-9
+ llc=-0.039                noimod=2                  ef=1.064
+ noia=9.5e+18              noib=1.0e5                noic=1.4e-12
+ em=3.0e+07                minr=1e-60                imax=0.01
+ imelt=0.01

     16: type=p
+ lmin=1.8e-007             lmax=5.000e-07-dxlp-dlmis wmin=2.2e-007
+ wmax=5.0000e-07-dxwp-dwmis                          tnom=25.0
+ version=3.24              tox=toxp+toxmis           toxm=4.08e-09
+ xj=1.7000001e-07          nch=3.9000000e17          lln=-1
+ lwn=1.0000000             wln=1.0000000             wwn=1.0000000
+ lint=1.4999999e-08        ll=0.00                   lw=0.00
+ lwl=0.00                  wint=5.0000000e-09        wl=0.00
+ ww=0.00                   wwl=0.00                  mobmod=1
+ binunit=2                 xl=-0.02e-6+dxlp+dlmis    xw=0.0+dxwp+dwmis
+ dwg=0.00                  dwb=0.00                  ldif=9.00e-08
+ hdif=hdifp                rsh=rshp                  rd=0
+ rs=0                      vth0=-0.4513863+dvthp+vthmis
+ lvth0=-9.7355810e-09+dlvthp                         wvth0=8.2035130e-09+dwvthp
+ pvth0=-2.8414808e-16+dpvthp                         k1=0.4651900
+ lk1=1.3789155e-08         wk1=9.2862840e-09         pk1=4.1227180e-15
+ k2=5.9709800e-02+dk2p     lk2=-3.1069460e-09+dlk2p  wk2=-4.3519210e-09
+ pk2=-2.3103772e-15        k3=0.00                   dvt0=0.00
+ dvt1=0.00                 dvt2=0.00                 dvt0w=0.00
+ dvt1w=0.00                dvt2w=0.00                nlx=0.00
+ w0=0.00                   k3b=0.00                  vsat=1.3081255e05+dvsatp
+ wvsat=0+dwvsatp           lvsat=-3.6563360e-04      ua=2.0400983e-09
+ lua=-2.6402067e-16        wua=-4.6294430e-16        pua=6.3047610e-23
+ ub=-4.9040330e-19         lub=2.6345733e-25         wub=1.5438073e-25
+ pub=-7.5226180e-32        uc=-2.8037866e-10         luc=3.3408970e-17
+ wuc=6.3648470e-18         puc=-8.7588340e-24        rdsw=5.3000000e02
+ prwb=0.00                 prwg=0.00                 wr=1.0000000
+ u0=1.0799064e-02+du0p     lu0=-3.5662620e-10+dlu0p  wu0=-1.0079994e-09+dwu0p
+ pu0=1.3574996e-16+dpu0p   a0=1.4167303              la0=7.2330520e-09
+ wa0=4.1169190e-08         pa0=-6.0720430e-15        keta=3.1593680e-02
+ lketa=-5.3067750e-09      wketa=-1.4490222e-09      pketa=7.4567200e-16
+ a1=0.00                   a2=0.4000000              ags=3.6250000e-02
+ lags=-7.3124990e-09       b0=0.00                   b1=0.00
+ voff=-0.1287204+dvoffp    lvoff=-6.1987190e-09+dlvoffp
+ wvoff=2.8606606e-09+dwvoffp                         pvoff=1.4541431e-15+dpvoffp
+ nfactor=1.0000000+dnfactorp                         pnfactor=0+dpnfactorp
+ wnfactor=0+dwnfactorp     lnfactor=0+dlnfactorp     cit=8.5343770e-05
+ lcit=5.4295310e-11        cdsc=0.00                 cdscb=0.00
+ cdscd=-6.4492230e-05      lcdscd=2.9021494e-11      wcdscd=-1.4183201e-11
+ pcdscd=6.3824410e-18      eta0=-4.6875020e-04+deta0p
+ peta0=0+dpeta0p           weta0=0+dweta0p           leta0=2.5593758e-10+dleta0p
+ etab=6.7187530e-04        letab=-3.4734380e-10      dsub=0.00
+ pclm=0.9648299            lpclm=1.5826547e-08       wpclm=4.6342220e-09
+ ppclm=-2.0853998e-15      pdiblc1=1.0000000e-06     pdiblc2=5.9374990e-03
+ lpdiblc2=1.8281252e-09    pdiblcb=1.0000000e-02     drout=0.00
+ pscbe1=3.5000000e08       pscbe2=5.0000000e-07      pvag=0.00
+ delta=1.0000000e-02       alpha0=0.00               alpha1=6.8730453846
+ beta0=22.67827            kt1=-0.2130934            lkt1=-1.9244071e-09
+ wkt1=-3.6719870e-09       pkt1=-9.7588050e-16       kt2=-3.5890840e-02
+ lkt2=2.8778120e-09        wkt2=4.2090850e-09        pkt2=-1.0643102e-15
+ at=1.0000000e04           ute=-0.5893072            lute=-1.7460413e-09
+ wute=-5.1916390e-08       pute=5.9684110e-15        ua1=1.2240000e-09
+ ub1=-1.4433942e-18        lub1=-1.5074642e-26       wub1=-2.3274574e-27
+ pub1=1.9106841e-32        uc1=2.0396977e-10         luc1=-2.4758267e-17
+ wuc1=-3.5824470e-17       puc1=6.1537120e-24        kt1l=0.00
+ prt=0                     cj=cjp                    pb=0.895226
+ mj=0.4476                 cjsw=cjswp                pbsw=0.895226
+ mjsw=0.3683619            cjswg=cjswgp              pbswg=0.895226
+ mjswg=0.3683619           cgdo=cgop                 cgso=cgop
+ tcj=0.0009739001          tcjsw=0.0004130718        tcjswg=0.0004130718
+ tpb=0.001572025           tpbsw=0.001572025         tpbswg=0.001572025
+ js=2.50e-07               jsw=1.2e-12               n=1
+ xti=3                     capmod=3                  nqsmod=0
+ xpart=1                   cf=0                      tlev=1
+ tlevc=1                   dlc=2e-9                  llc=-0.039
+ noimod=2                  ef=1.064                  noia=9.5e+18
+ noib=1.0e5                noic=1.4e-12              em=3.0e+07
+ minr=1e-60                imax=0.01                 imelt=0.01

     }
ends pch_mis

endsection mos

section mos_3v
//  *****************************************************************************************
//
//             *
//                      3.3V I/O baseband DEVICE MODELS
//             *
//
//             *
//  *****************************************************************************************

model nch3 bsim3v3  {
 1: type=n
+ lmin=1.000e-05 - dxln3 lmax=20.001e-006 wmin=1.0000e-05 - dxwn3
+ wmax=900.001e-6 tnom=25.0 version=3.24
+ tox=toxn3 toxm=6.8e-09 xj=1.7000001e-07
+ nch=5.2600000e17 lln=-1 lwn=1.0000000
+ wln=1.0000000 wwn=1.0000000 lint=4.0000000e-08
+ ll=0.00 lw=0.00 lwl=0.00
+ wint=1.4999999e-08 wl=0.00 ww=0.00
+ wwl=0.00 mobmod=1 binunit=2
+ xl= - 0.02e-6 + dxln3 xw=0.0 + dxwn3 dwg=0.00
+ dwb=0.00 ldif=9.00e-08
+ hdif=hdifn3 rsh=rshn3 rd=0
+ rs=0 vth0=0.7411730 + dvthn3 pvth0=0 + dpvthn3
+ wvth0=0 + dwvthn3 lvth0=0 + dlvthn3 k1=0.8520129
+ k2=3.2049370e-02 + dk2n3 lk2=0 + dlk2n3
+ k3=0.00 dvt0=0.00 dvt1=0.00
+ dvt2=0.00 dvt0w=0.00 dvt1w=0.00
+ dvt2w=0.00 nlx=0.00 w0=0.00
+ k3b=0.00 vsat=1.0000000e05 + dvsatn3
+ wvsat=0 + dwvsatn3 ua=-6.5967100e-10 ub=2.3514212e-18
+ uc=1.0151108e-10 rdsw=5.4500000e02 prwb=0.00
+ prwg=0.00 wr=1.0000000 u0=4.0383610e-02 + du0n3
+ pu0=0 + dpu0n3 wu0=0 + dwu0n3 lu0=0 + dlu0n3
+ a0=0.5957787 keta=1.0636362e-02 a1=0.00
+ a2=0.9900000 ags=2.0000000e-02 b0=0.00
+ b1=0.00 voff= - 0.1273081 + dvoffn3
+ pvoff=0 + dpvoffn3 wvoff=0 + dwvoffn3 lvoff=0 + dlvoffn3
+ nfactor=1.0000000 + dnfactorn3 pnfactor=0 + dpnfactorn3
+ wnfactor=0 + dwnfactorn3 lnfactor=0 + dlnfactorn3
+ cit=3.2298330e-04 cdsc=0.00 cdscb=0.00
+ cdscd=0.00 eta0=1.0000000e-05 + deta0n3
+ peta0=0 + dpeta0n3 weta0=0 + dweta0n3 leta0=0 + dleta0n3
+ etab=-1.0000000e-05 dsub=0.00 pclm=0.5000001
+ pdiblc1=1.0000000e-06 pdiblc2=5.0000000e-04 pdiblcb=1.0000000e-02
+ drout=0.00 pscbe1=2.0000000e08 pscbe2=1.0000000e-06
+ pvag=0.00 delta=1.0000000e-02 alpha0=0.0
+ alpha1=7.049416 beta0=21.5673 kt1=-0.2967474
+ kt2=-3.0051107e-02 at=2.0000000e04 ute=-1.3699325
+ ua1=2.0399999e-09 ub1=-2.3240355e-18 uc1=-2.5228651e-11
+ kt1l=0.00 prt=0 cj=cjn3
+ pb=0.7076023 mj=0.3259624 cjsw=cjswn3
+ pbsw=0.7076023 mjsw=0.1513672 cjswg=cjswgn3
+ pbswg=0.7076023 mjswg=0.3513672 cgdo=cgon3
+ cgso=cgon3 tcj=0.0009923959 tcjsw=0.0005019466
+ tcjswg=0.0005019466 tpb=0.001687207 tpbsw=0.001687207
+ tpbswg=0.001687207 js=3.93e-07 jsw=1.43e-12
+ n=1 xti=3 capmod=3
+ nqsmod=0 xpart=1 cf=0
+ tlev=1 tlevc=1
+ llc=-0.0165 noimod=2
+ noia=1.0e20 noib=4.0e04 noic=-4.0e-13
+ em=3.0e07 ef=0.881
+ minr=1e-60 imax=0.01 imelt=0.01

 2: type=n
+ lmin=1.200e-06 - dxln3 lmax=1.000e-05 - dxln3 wmin=1.0000e-05 - dxwn3
+ wmax=900.001e-6 tnom=25.0 version=3.24
+ tox=toxn3 toxm=6.8e-09 xj=1.7000001e-07
+ nch=5.2600000e17 lln=-1 lwn=1.0000000
+ wln=1.0000000 wwn=1.0000000 lint=4.0000000e-08
+ ll=0.00 lw=0.00 lwl=0.00
+ wint=1.4999999e-08 wl=0.00 ww=0.00
+ wwl=0.00 mobmod=1 binunit=2
+ xl= - 0.02e-6 + dxln3 xw=0.0 + dxwn3 dwg=0.00
+ dwb=0.00 ldif=9.00e-08
+ hdif=hdifn3 rsh=rshn3 rd=0
+ rs=0 vth0=0.7338805 + dvthn3 pvth0=0 + dpvthn3
+ wvth0=0 + dwvthn3 lvth0=7.2196430e-08 + dlvthn3
+ k1=0.8436294 lk1=8.2996260e-08 k2=3.5836430e-02 + dk2n3
+ lk2= - 3.7491980e-08 + dlk2n3 k3=0.00
+ dvt0=0.00 dvt1=0.00 dvt2=0.00
+ dvt0w=0.00 dvt1w=0.00 dvt2w=0.00
+ nlx=0.00 w0=0.00 k3b=0.00
+ vsat=1.0087500e05 + dvsatn3 wvsat=0 + dwvsatn3
+ lvsat=-8.6625000e-03 ua=-6.5715190e-10 lua=-2.4938983e-17
+ ub=2.3501459e-18 lub=1.2625015e-26 uc=9.9987010e-11
+ luc=1.5088319e-17 rdsw=5.4500000e02 prwb=0.00
+ prwg=0.00 wr=1.0000000 u0=4.0144190e-02 + du0n3
+ pu0=0 + dpu0n3 wu0=0 + dwu0n3
+ lu0=2.3703481e-09 + dlu0n3 a0=0.5985498
+ la0=-2.7434131e-08 keta=1.3293392e-02 lketa=-2.6304601e-08
+ a1=0.00 a2=0.9900000 ags=2.0000000e-02
+ b0=0.00 b1=0.00
+ voff= - 0.1288763 + dvoffn3 pvoff=0 + dpvoffn3
+ wvoff=0 + dwvoffn3 lvoff=1.5525753e-08 + dlvoffn3
+ nfactor=1.0000000 + dnfactorn3 pnfactor=0 + dpnfactorn3
+ wnfactor=0 + dwnfactorn3 lnfactor=0 + dlnfactorn3
+ cit=2.9848100e-04 lcit=2.4257210e-10 cdsc=0.00
+ cdscb=0.00 cdscd=0.00
+ eta0=5.0055810e-06 + deta0n3 peta0=0 + dpeta0n3
+ weta0=0 + dweta0n3 leta0=4.9444760e-11 + dleta0n3
+ etab=-5.0055810e-06 letab=-4.9444760e-11 dsub=0.00
+ pclm=0.4766459 lpclm=2.3120668e-07 pdiblc1=1.0000000e-06
+ pdiblc2=4.3750000e-04 lpdiblc2=6.1875000e-10 pdiblcb=1.0000000e-02
+ drout=0.00 pscbe1=1.8500000e08 lpscbe1=1.4850000e02
+ pscbe2=1.0000000e-06 pvag=0.00 delta=1.0000000e-02
+ alpha0=0.0 alpha1=7.049416 beta0=21.5673
+ kt1=-0.2975682 lkt1=8.1267750e-09 kt2=-3.0177854e-02
+ lkt2=1.2547903e-09 at=2.0000000e04 ute=-1.3824263
+ lute=1.2368807e-07 ua1=2.0399999e-09 ub1=-2.3458511e-18
+ lub1=2.1597545e-25 uc1=-2.8060729e-11 luc1=2.8037565e-17
+ kt1l=0.00 prt=0 cj=cjn3
+ pb=0.7076023 mj=0.3259624 cjsw=cjswn3
+ pbsw=0.7076023 mjsw=0.1513672 cjswg=cjswgn3
+ pbswg=0.7076023 mjswg=0.3513672 cgdo=cgon3
+ cgso=cgon3 tcj=0.0009923959 tcjsw=0.0005019466
+ tcjswg=0.0005019466 tpb=0.001687207 tpbsw=0.001687207
+ tpbswg=0.001687207 js=3.93e-07 jsw=1.43e-12
+ n=1 xti=3 capmod=3
+ nqsmod=0 xpart=1 cf=0
+ tlev=1 tlevc=1
+ llc=-0.0165 noimod=2
+ noia=1.0e20 noib=4.0e04 noic=-4.0e-13
+ em=3.0e07 ef=0.881
+ minr=1e-60 imax=0.01 imelt=0.01

 3: type=n
+ lmin=5.000e-07 - dxln3 lmax=1.200e-06 - dxln3 wmin=1.0000e-05 - dxwn3
+ wmax=900.001e-6 tnom=25.0 version=3.24
+ tox=toxn3 toxm=6.8e-09 xj=1.7000001e-07
+ nch=5.2600000e17 lln=-1 lwn=1.0000000
+ wln=1.0000000 wwn=1.0000000 lint=4.0000000e-08
+ ll=0.00 lw=0.00 lwl=0.00
+ wint=1.4999999e-08 wl=0.00 ww=0.00
+ wwl=0.00 mobmod=1 binunit=2
+ xl= - 0.02e-6 + dxln3 xw=0.0 + dxwn3 dwg=0.00
+ dwb=0.00 ldif=9.00e-08
+ hdif=hdifn3 rsh=rshn3 rd=0
+ rs=0 vth0=0.7854808 + dvthn3 pvth0=0 + dpvthn3
+ wvth0=0 + dwvthn3 lvth0=1.5436049e-08 + dlvthn3
+ k1=0.8725621 lk1=5.1170270e-08 k2=2.6585609e-02 + dk2n3
+ lk2= - 2.7316075e-08 + dlk2n3 k3=0.00
+ dvt0=0.00 dvt1=0.00 dvt2=0.00
+ dvt0w=0.00 dvt1w=0.00 dvt2w=0.00
+ nlx=0.00 w0=0.00 k3b=0.00
+ vsat=9.4142860e04 + dvsatn3 wvsat=0 + dwvsatn3
+ lvsat=-1.2571429e-03 ua=-5.5044020e-10 lua=-1.4232186e-16
+ ub=2.2213255e-18 lub=1.5432739e-25 uc=8.6765090e-11
+ luc=2.9632438e-17 rdsw=5.4500000e02 prwb=0.00
+ prwg=0.00 wr=1.0000000 u0=4.1177810e-02 + du0n3
+ pu0=0 + dpu0n3 wu0=0 + dwu0n3
+ lu0=1.2333661e-09 + dlu0n3 a0=0.5002358
+ la0=8.0711320e-08 keta=3.0733263e-03 lketa=-1.5062529e-08
+ a1=0.00 a2=0.9900000 ags=4.2857150e-02
+ lags=-2.5142864e-08 b0=0.00 b1=0.00
+ voff= - 0.1181122 + dvoffn3 pvoff=0 + dpvoffn3
+ wvoff=0 + dwvoffn3 lvoff=3.6851710e-09 + dlvoffn3
+ nfactor=1.0000000 + dnfactorn3 pnfactor=0 + dpnfactorn3
+ wnfactor=0 + dwnfactorn3 lnfactor=0 + dlnfactorn3
+ cit=5.2695760e-04 lcit=-8.7521730e-12 cdsc=0.00
+ cdscb=0.00 cdscd=0.00
+ eta0= - 2.0721287e-04 + deta0n3 peta0=0 + dpeta0n3
+ weta0=0 + dweta0n3 leta0=2.8288508e-10 + dleta0n3
+ etab=2.0721287e-04 letab=-2.8288508e-10 dsub=0.00
+ pclm=0.6683022 lpclm=2.0384716e-08 pdiblc1=1.0000000e-06
+ pdiblc2=9.9999980e-04 pdiblcb=1.0000000e-02 drout=0.00
+ pscbe1=3.0285712e08 lpscbe1=18.8571820 pscbe2=1.0000000e-06
+ pvag=0.00 delta=1.0000000e-02 alpha0=0.0
+ alpha1=7.049416 beta0=21.5673 kt1=-0.3058816
+ lkt1=1.7271480e-08 kt2=-3.2605510e-02 lkt2=3.9252180e-09
+ at=2.0000000e04 ute=-1.3841497 lute=1.2558385e-07
+ ua1=2.0399999e-09 ub1=-2.6782768e-18 lub1=5.8164370e-25
+ uc1=-7.4947920e-11 luc1=7.9613470e-17 kt1l=0.00
+ prt=0 cj=cjn3 pb=0.7076023
+ mj=0.3259624 cjsw=cjswn3 pbsw=0.7076023
+ mjsw=0.1513672 cjswg=cjswgn3 pbswg=0.7076023
+ mjswg=0.3513672 cgdo=cgon3 cgso=cgon3
+ tcj=0.0009923959 tcjsw=0.0005019466 tcjswg=0.0005019466
+ tpb=0.001687207 tpbsw=0.001687207 tpbswg=0.001687207
+ js=3.93e-07 jsw=1.43e-12 n=1
+ xti=3 capmod=3 nqsmod=0
+ xpart=1 cf=0 tlev=1
+ tlevc=1
+ llc=-0.0165 noimod=2 noia=1.0e20
+ noib=4.0e04 noic=-4.0e-13 em=3.0e07
+ ef=0.881
+ minr=1e-60 imax=0.01 imelt=0.01

 4: type=n
+ lmin=3.5e-007 lmax=5.000e-07 - dxln3 wmin=1.0000e-05 - dxwn3
+ wmax=900.001e-6 tnom=25.0 version=3.24
+ tox=toxn3 toxm=6.8e-09 xj=1.7000001e-07
+ nch=5.2600000e17 lln=-1 lwn=1.0000000
+ wln=1.0000000 wwn=1.0000000 lint=4.0000000e-08
+ ll=0.00 lw=0.00 lwl=0.00
+ wint=1.4999999e-08 wl=0.00 ww=0.00
+ wwl=0.00 mobmod=1 binunit=2
+ xl= - 0.02e-6 + dxln3 xw=0.0 + dxwn3 dwg=0.00
+ dwb=0.00 ldif=9.00e-08
+ hdif=hdifn3 rsh=rshn3 rd=0
+ rs=0 vth0=0.8656338 + dvthn3 pvth0=0 + dpvthn3
+ wvth0=0 + dwvthn3 lvth0= - 1.6625165e-08 + dlvthn3
+ k1=0.7380362 lk1=1.0498064e-07 k2=0.1905548 + dk2n3
+ lk2= - 9.2903750e-08 + dlk2n3 k3=0.00
+ dvt0=0.00 dvt1=0.00 dvt2=0.00
+ dvt0w=0.00 dvt1w=0.00 dvt2w=0.00
+ nlx=0.00 w0=0.00 k3b=0.00
+ vsat=9.2662950e04 + dvsatn3 wvsat=0 + dwvsatn3
+ lvsat=-6.6517710e-04 ua=-7.6742930e-10 lua=-5.5526210e-17
+ ub=2.1708317e-18 lub=1.7452491e-25 uc=2.5100996e-10
+ luc=-3.6065510e-17 rdsw=5.4500000e02 prwb=0.00
+ prwg=0.00 wr=1.0000000 u0=4.2647680e-02 + du0n3
+ pu0=0 + dpu0n3 wu0=0 + dwu0n3
+ lu0=6.4541630e-10 + dlu0n3 a0=0.8895671
+ la0=-7.5021190e-08 keta=-5.8208280e-02 lketa=9.4501150e-09
+ a1=0.00 a2=0.9900000 ags=-2.0000029e-02
+ b0=0.00 b1=0.00
+ voff= - 0.1009514 + dvoffn3 pvoff=0 + dpvoffn3
+ wvoff=0 + dwvoffn3 lvoff= - 3.1791380e-09 + dlvoffn3
+ nfactor=1.0000000 + dnfactorn3 pnfactor=0 + dpnfactorn3
+ wnfactor=0 + dwnfactorn3 lnfactor=0 + dlnfactorn3
+ cit=4.9120500e-04 lcit=5.5488980e-12 cdsc=0.00
+ cdscb=0.00 cdscd=0.00
+ eta0= - 1.1666669e-03 + deta0n3 peta0=0 + dpeta0n3
+ weta0=0 + dweta0n3 leta0=6.6666670e-10 + dleta0n3
+ etab=3.6657390e-03 letab=-1.6662953e-09 dsub=0.00
+ pclm=-0.1426817 lpclm=3.4477830e-07 pdiblc1=1.0000000e-06
+ pdiblc2=-1.0661089e-02 lpdiblc2=4.6644360e-09 pdiblcb=1.0000000e-02
+ drout=0.00 pscbe1=3.5000020e08 pscbe2=1.0000000e-06
+ pvag=0.00 delta=1.0000000e-02 alpha0=0.0
+ alpha1=7.049416 beta0=21.5673 kt1=-0.2689408
+ lkt1=2.4951499e-09 kt2=-1.7957341e-02 lkt2=-1.9340516e-09
+ at=2.0000000e04 ute=-1.0052726 lute=-2.5966962e-08
+ ua1=2.0399999e-09 ub1=-1.6034720e-18 lub1=1.5172175e-25
+ uc1=9.0686240e-11 luc1=1.3359813e-17 kt1l=0.00
+ prt=0 cj=cjn3 pb=0.7076023
+ mj=0.3259624 cjsw=cjswn3 pbsw=0.7076023
+ mjsw=0.1513672 cjswg=cjswgn3 pbswg=0.7076023
+ mjswg=0.3513672 cgdo=cgon3 cgso=cgon3
+ tcj=0.0009923959 tcjsw=0.0005019466 tcjswg=0.0005019466
+ tpb=0.001687207 tpbsw=0.001687207 tpbswg=0.001687207
+ js=3.93e-07 jsw=1.43e-12 n=1
+ xti=3 capmod=3 nqsmod=0
+ xpart=1 cf=0 tlev=1
+ tlevc=1
+ llc=-0.0165 noimod=2 noia=1.0e20
+ noib=4.0e04 noic=-4.0e-13 em=3.0e07
+ ef=0.881
+ minr=1e-60 imax=0.01 imelt=0.01

 5: type=n
+ lmin=1.000e-05 - dxln3 lmax=20.001e-006 wmin=1.2000e-06 - dxwn3
+ wmax=1.0000e-05 - dxwn3 tnom=25.0 version=3.24
+ tox=toxn3 toxm=6.8e-09 xj=1.7000001e-07
+ nch=5.2600000e17 lln=-1 lwn=1.0000000
+ wln=1.0000000 wwn=1.0000000 lint=4.0000000e-08
+ ll=0.00 lw=0.00 lwl=0.00
+ wint=1.4999999e-08 wl=0.00 ww=0.00
+ wwl=0.00 mobmod=1 binunit=2
+ xl= - 0.02e-6 + dxln3 xw=0.0 + dxwn3 dwg=0.00
+ dwb=0.00 ldif=9.00e-08
+ hdif=hdifn3 rsh=rshn3 rd=0
+ rs=0 vth0=0.7412278 + dvthn3 pvth0=0 + dpvthn3
+ lvth0=0 + dlvthn3 wvth0= - 5.4619160e-10 + dwvthn3
+ k1=0.8508129 wk1=1.1963754e-08 k2=3.1879250e-02 + dk2n3
+ lk2=0 + dlk2n3 wk2=1.6960789e-09 k3=0.00
+ dvt0=0.00 dvt1=0.00 dvt2=0.00
+ dvt0w=0.00 dvt1w=0.00 dvt2w=0.00
+ nlx=0.00 w0=0.00 k3b=0.00
+ vsat=1.0000000e05 + dvsatn3 wvsat=0 + dwvsatn3
+ ua=-6.5888360e-10 wua=-7.8505910e-18 ub=2.3875394e-18
+ wub=-3.6009940e-25 uc=1.0341122e-10 wuc=-1.8944324e-17
+ rdsw=5.4500000e02 prwb=0.00 prwg=0.00
+ wr=1.0000000 u0=4.0690960e-02 + du0n3
+ pu0=0 + dpu0n3 lu0=0 + dlu0n3
+ wu0= - 3.0642096e-09 + dwu0n3 a0=0.5914139
+ wa0=4.3517560e-08 keta=1.0701262e-02 wketa=-6.4705320e-10
+ a1=0.00 a2=0.9900000 ags=2.0000000e-02
+ b0=0.00 b1=0.00
+ voff= - 0.1275286 + dvoffn3 pvoff=0 + dpvoffn3
+ lvoff=0 + dlvoffn3 wvoff=2.1983364e-09 + dwvoffn3
+ nfactor=1.0000000 + dnfactorn3 pnfactor=0 + dpnfactorn3
+ wnfactor=0 + dwnfactorn3 lnfactor=0 + dlnfactorn3
+ cit=3.2352310e-04 wcit=-5.3825510e-12 cdsc=0.00
+ cdscb=0.00 cdscd=0.00
+ eta0=1.0000000e-05 + deta0n3 peta0=0 + dpeta0n3
+ weta0=0 + dweta0n3 leta0=0 + dleta0n3 etab=-1.0000000e-05
+ dsub=0.00 pclm=0.5000001 pdiblc1=1.0000000e-06
+ pdiblc2=5.0000000e-04 pdiblcb=1.0000000e-02 drout=0.00
+ pscbe1=2.0000000e08 pscbe2=1.0000000e-06 pvag=0.00
+ delta=1.0000000e-02 alpha0=0.0 alpha1=7.049416
+ beta0=21.5673 kt1=-0.2959924 wkt1=-7.5268250e-09
+ kt2=-2.9950516e-02 wkt2=-1.0028854e-09 at=2.0000000e04
+ ute=-1.3781972 wute=8.2399010e-08 ua1=2.0399999e-09
+ ub1=-2.3223396e-18 wub1=-1.6908192e-26 uc1=-1.9919816e-11
+ wuc1=-5.2929100e-17 kt1l=0.00 prt=0
+ cj=cjn3 pb=0.7076023 mj=0.3259624
+ cjsw=cjswn3 pbsw=0.7076023 mjsw=0.1513672
+ cjswg=cjswgn3 pbswg=0.7076023 mjswg=0.3513672
+ cgdo=cgon3 cgso=cgon3 tcj=0.0009923959
+ tcjsw=0.0005019466 tcjswg=0.0005019466 tpb=0.001687207
+ tpbsw=0.001687207 tpbswg=0.001687207 js=3.93e-07
+ jsw=1.43e-12 n=1 xti=3
+ capmod=3 nqsmod=0 xpart=1
+ cf=0 tlev=1 tlevc=1
+ llc=-0.0165
+ noimod=2 noia=1.0e20 noib=4.0e04
+ noic=-4.0e-13 em=3.0e07 ef=0.881
+ minr=1e-60 imax=0.01 imelt=0.01

 6: type=n
+ lmin=1.200e-06 - dxln3 lmax=1.000e-05 - dxln3 wmin=1.2000e-06 - dxwn3
+ wmax=1.0000e-05 - dxwn3 tnom=25.0 version=3.24
+ tox=toxn3 toxm=6.8e-09 xj=1.7000001e-07
+ nch=5.2600000e17 lln=-1 lwn=1.0000000
+ wln=1.0000000 wwn=1.0000000 lint=4.0000000e-08
+ ll=0.00 lw=0.00 lwl=0.00
+ wint=1.4999999e-08 wl=0.00 ww=0.00
+ wwl=0.00 mobmod=1 binunit=2
+ xl= - 0.02e-6 + dxln3 xw=0.0 + dxwn3 dwg=0.00
+ dwb=0.00 ldif=9.00e-08
+ hdif=hdifn3 rsh=rshn3 rd=0
+ rs=0 vth0=0.7337149 + dvthn3
+ lvth0=7.4378140e-08 + dlvthn3
+ wvth0=1.6509301e-09 + dwvthn3
+ pvth0= - 2.1751505e-14 + dpvthn3 k1=0.8419480
+ lk1=8.7762780e-08 wk1=1.6763977e-08 pk1=-4.7522210e-14
+ k2=3.5826360e-02 + dk2n3
+ lk2= - 3.9076370e-08 + dlk2n3 wk2=1.0048508e-10
+ pk2=1.5796389e-14 k3=0.00 dvt0=0.00
+ dvt1=0.00 dvt2=0.00 dvt0w=0.00
+ dvt1w=0.00 dvt2w=0.00 nlx=0.00
+ w0=0.00 k3b=0.00
+ vsat=1.0087500e05 + dvsatn3 wvsat=0 + dwvsatn3
+ lvsat=-8.6625010e-03 ua=-6.5616190e-10 lua=-2.6944907e-17
+ wua=-9.8707010e-18 pua=1.9999060e-23 ub=2.3849762e-18
+ lub=2.5376364e-26 wub=-3.4725790e-25 pub=-1.2713090e-31
+ uc=1.0178221e-10 luc=1.6127195e-17 wuc=-1.7898101e-17
+ puc=-1.0357598e-23 rdsw=5.4500000e02 prwb=0.00
+ prwg=0.00 wr=1.0000000 u0=4.0439300e-02 + du0n3
+ lu0=2.4913751e-09 + dlu0n3
+ wu0= - 2.9423268e-09 + dwu0n3
+ pu0= - 1.2066391e-15 + dpu0n3 a0=0.5931649
+ la0=-1.7334720e-08 wa0=5.3688390e-08 pa0=-1.0069116e-13
+ keta=1.3365778e-02 lketa=-2.6378700e-08 wketa=-7.2167630e-10
+ pketa=7.3875800e-16 a1=0.00 a2=0.9900000
+ ags=2.0000000e-02 b0=0.00 b1=0.00
+ voff= - 0.1290965 + dvoffn3
+ lvoff=1.5522346e-08 + dlvoffn3
+ wvoff=2.1949056e-09 + dwvoffn3
+ pvoff=3.3964270e-17 + dpvoffn3
+ nfactor=1.0000000 + dnfactorn3 pnfactor=0 + dpnfactorn3
+ wnfactor=0 + dwnfactorn3 lnfactor=0 + dlnfactorn3
+ cit=2.9909017e-04 lcit=2.4188637e-10 wcit=-6.0731490e-12
+ pcit=6.8368810e-18 cdsc=0.00 cdscb=0.00
+ cdscd=0.00 eta0=4.3415470e-06 + deta0n3
+ leta0=5.6018670e-11 + dleta0n3
+ weta0=6.6203900e-12 + dweta0n3
+ peta0= - 6.5541850e-17 + dpeta0n3 etab=-4.3415470e-06
+ letab=-5.6018670e-11 wetab=-6.6203900e-12 petab=6.5541850e-17
+ dsub=0.00 pclm=0.4771902 lpclm=2.2581794e-07
+ wpclm=-5.4269150e-09 ppclm=5.3725680e-14 pdiblc1=1.0000000e-06
+ pdiblc2=4.3750000e-04 lpdiblc2=6.1875000e-10 pdiblcb=1.0000000e-02
+ drout=0.00 pscbe1=1.8499998e08 lpscbe1=1.4850002e02
+ pscbe2=1.0000000e-06 pvag=0.00 delta=1.0000000e-02
+ alpha0=0.0 alpha1=7.049416 beta0=21.5673
+ kt1=-0.2967275 lkt1=7.2770190e-09 wkt1=-8.3825920e-09
+ pkt1=8.4720740e-15 kt2=-3.0061465e-02 lkt2=1.0983974e-09
+ wkt2=-1.1603842e-09 pkt2=1.5592368e-15 at=2.0000000e04
+ ute=-1.3914689 lute=1.3138961e-07 wute=9.0155010e-08
+ pute=-7.6784330e-14 ua1=2.0399999e-09 ub1=-2.3428319e-18
+ lub1=2.0287447e-25 wub1=-3.0101820e-26 pub1=1.3061675e-31
+ uc1=-2.2305425e-11 luc1=2.3617550e-17 wuc1=-5.7380370e-17
+ puc1=4.4067530e-23 kt1l=0.00 prt=0
+ cj=cjn3 pb=0.7076023 mj=0.3259624
+ cjsw=cjswn3 pbsw=0.7076023 mjsw=0.1513672
+ cjswg=cjswgn3 pbswg=0.7076023 mjswg=0.3513672
+ cgdo=cgon3 cgso=cgon3 tcj=0.0009923959
+ tcjsw=0.0005019466 tcjswg=0.0005019466 tpb=0.001687207
+ tpbsw=0.001687207 tpbswg=0.001687207 js=3.93e-07
+ jsw=1.43e-12 n=1 xti=3
+ capmod=3 nqsmod=0 xpart=1
+ cf=0 tlev=1 tlevc=1
+ llc=-0.0165
+ noimod=2 noia=1.0e20 noib=4.0e04
+ noic=-4.0e-13 em=3.0e07 ef=0.881
+ minr=1e-60 imax=0.01 imelt=0.01

 7: type=n
+ lmin=5.000e-07 - dxln3 lmax=1.200e-06 - dxln3 wmin=1.2000e-06 - dxwn3
+ wmax=1.0000e-05 - dxwn3 tnom=25.0 version=3.24
+ tox=toxn3 toxm=6.8e-09 xj=1.7000001e-07
+ nch=5.2600000e17 lln=-1 lwn=1.0000000
+ wln=1.0000000 wwn=1.0000000 lint=4.0000000e-08
+ ll=0.00 lw=0.00 lwl=0.00
+ wint=1.4999999e-08 wl=0.00 ww=0.00
+ wwl=0.00 mobmod=1 binunit=2
+ xl= - 0.02e-6 + dxln3 xw=0.0 + dxwn3 dwg=0.00
+ dwb=0.00 ldif=9.00e-08
+ hdif=hdifn3 rsh=rshn3 rd=0
+ rs=0 vth0=0.7882218 + dvthn3
+ lvth0=1.4420463e-08 + dlvthn3
+ wvth0= - 2.7328070e-08 + dwvthn3
+ pvth0=1.0125395e-14 + dpvthn3 k1=0.8741527
+ lk1=5.2337620e-08 wk1=-1.5857541e-08 pk1=-1.1638531e-14
+ k2=2.5716120e-02 + dk2n3
+ lk2= - 2.7955116e-08 + dlk2n3 wk2=8.6687970e-09
+ pk2=6.3712410e-15 k3=0.00 dvt0=0.00
+ dvt1=0.00 dvt2=0.00 dvt0w=0.00
+ dvt1w=0.00 dvt2w=0.00 nlx=0.00
+ w0=0.00 k3b=0.00
+ vsat=9.4142860e04 + dvsatn3 wvsat=0 + dwvsatn3
+ lvsat=-1.2571429e-03 ua=-5.5216260e-10 lua=-1.4134407e-16
+ wua=1.7172625e-17 pua=-9.7485960e-24 ub=2.2626136e-18
+ lub=1.5997525e-25 wub=-4.1164150e-25 pub=-5.6308880e-32
+ uc=8.8400200e-11 luc=3.0847405e-17 wuc=-1.6302085e-17
+ puc=-1.2113212e-23 rdsw=5.4500000e02 prwb=0.00
+ prwg=0.00 wr=1.0000000 u0=4.1623130e-02 + du0n3
+ lu0=1.1891720e-09 + dlu0n3
+ wu0= - 4.4398320e-09 + dwu0n3
+ pu0=4.4061720e-16 + dpu0n3 a0=0.5080709
+ la0=7.6268660e-08 wa0=-7.8115730e-08 pa0=4.4293360e-14
+ keta=3.3942350e-03 lketa=-1.5410004e-08 wketa=-3.1994660e-09
+ pketa=3.4643260e-15 a1=0.00 a2=0.9900000
+ ags=4.2857140e-02 lags=-2.5142862e-08 b0=0.00
+ b1=0.00 voff= - 0.1178869 + dvoffn3
+ lvoff=3.1917740e-09 + dlvoffn3
+ wvoff= - 2.2461877e-09 + dwvoffn3
+ pvoff=4.9191660e-15 + dpvoffn3
+ nfactor=1.0000000 + dnfactorn3 pnfactor=0 + dpnfactorn3
+ wnfactor=0 + dwnfactorn3 lnfactor=0 + dlnfactorn3
+ cit=5.2714030e-04 lcit=-8.9688470e-12 wcit=-1.8216587e-12
+ pcit=2.1602446e-18 cdsc=0.00 cdscb=0.00
+ cdscd=0.00 eta0= - 1.9886503e-04 + deta0n3
+ leta0=2.7954594e-10 + dleta0n3
+ weta0= - 8.3227900e-11 + dweta0n3
+ peta0=3.3291270e-17 + dpeta0n3 etab=1.9886503e-04
+ letab=-2.7954594e-10 wetab=8.3227900e-11 petab=-3.3291270e-17
+ dsub=0.00 pclm=0.6760895 lpclm=7.0287020e-09
+ wpclm=-7.7639390e-08 ppclm=1.3315938e-13 pdiblc1=1.0000000e-06
+ pdiblc2=1.0042337e-03 lpdiblc2=-4.6571500e-12 wpdiblc2=-4.2211370e-11
+ ppdiblc2=4.6432500e-17 pdiblcb=1.0000000e-02 drout=0.00
+ pscbe1=3.0285712e08 lpscbe1=18.8571820 pscbe2=1.0000000e-06
+ pvag=0.00 delta=1.0000000e-02 alpha0=0.0
+ alpha1=7.049416 beta0=21.5673 kt1=-0.3071715
+ lkt1=1.8765444e-08 wkt1=1.2860058e-08 pkt1=-1.4894836e-14
+ kt2=-3.2976900e-02 lkt2=4.3053730e-09 wkt2=3.7026910e-09
+ pkt2=-3.7901450e-15 at=2.0000000e04 ute=-1.4001315
+ lute=1.4091844e-07 wute=1.5933820e-07 pute=-1.5288584e-13
+ ua1=2.0399999e-09 ub1=-2.7388682e-18 lub1=6.3851440e-25
+ wub1=6.0409630e-25 pub1=-5.6700110e-31 uc1=-7.8913690e-11
+ luc1=8.5886630e-17 wuc1=3.9538620e-17 puc1=-6.2543340e-23
+ kt1l=0.00 prt=0 cj=cjn3
+ pb=0.7076023 mj=0.3259624 cjsw=cjswn3
+ pbsw=0.7076023 mjsw=0.1513672 cjswg=cjswgn3
+ pbswg=0.7076023 mjswg=0.3513672 cgdo=cgon3
+ cgso=cgon3 tcj=0.0009923959 tcjsw=0.0005019466
+ tcjswg=0.0005019466 tpb=0.001687207 tpbsw=0.001687207
+ tpbswg=0.001687207 js=3.93e-07 jsw=1.43e-12
+ n=1 xti=3 capmod=3
+ nqsmod=0 xpart=1 cf=0
+ tlev=1 tlevc=1
+ llc=-0.0165 noimod=2
+ noia=1.0e20 noib=4.0e04 noic=-4.0e-13
+ em=3.0e07 ef=0.881
+ minr=1e-60 imax=0.01 imelt=0.01

 8: type=n
+ lmin=3.5e-007 lmax=5.000e-07 - dxln3 wmin=1.2000e-06 - dxwn3
+ wmax=1.0000e-05 - dxwn3 tnom=25.0 version=3.24
+ tox=toxn3 toxm=6.8e-09 xj=1.7000001e-07
+ nch=5.2600000e17 lln=-1 lwn=1.0000000
+ wln=1.0000000 wwn=1.0000000 lint=4.0000000e-08
+ ll=0.00 lw=0.00 lwl=0.00
+ wint=1.4999999e-08 wl=0.00 ww=0.00
+ wwl=0.00 mobmod=1 binunit=2
+ xl= - 0.02e-6 + dxln3 xw=0.0 + dxwn3 dwg=0.00
+ dwb=0.00 ldif=9.00e-08
+ hdif=hdifn3 rsh=rshn3 rd=0
+ rs=0 vth0=0.8659324 + dvthn3
+ lvth0= - 1.6663769e-08 + dlvthn3
+ wvth0= - 2.9767808e-09 + dwvthn3
+ pvth0=3.8488080e-16 + dpvthn3 k1=0.7465155
+ lk1=1.0339250e-07 wk1=-8.4537670e-08 pk1=1.5833523e-14
+ k2=0.1900880 + dk2n3 lk2= - 9.3703870e-08 + dlk2n3
+ wk2=4.6535320e-09 pk2=7.9773500e-15 k3=0.00
+ dvt0=0.00 dvt1=0.00 dvt2=0.00
+ dvt0w=0.00 dvt1w=0.00 dvt2w=0.00
+ nlx=0.00 w0=0.00 k3b=0.00
+ vsat=9.3130330e04 + dvsatn3 lvsat=-8.5213050e-04
+ wvsat= - 4.6598160e-03 + dwvsatn3 pvsat=1.8639263e-09
+ ua=-6.7444880e-10 lua=-9.2429640e-17 wua=-9.2701740e-16
+ pua=3.6792740e-22 ub=2.1189834e-18 lub=2.1742727e-25
+ wub=5.1692720e-25 pub=-4.2773630e-31 uc=2.6250338e-10
+ luc=-3.8793870e-17 wuc=-1.1458971e-16 puc=2.7201846e-23
+ rdsw=5.4500000e02 prwb=0.00 prwg=0.00
+ wr=1.0000000 u0=4.3624590e-02 + du0n3
+ lu0=3.8858720e-10 + dlu0n3
+ wu0= - 9.7397600e-09 + dwu0n3
+ pu0=2.5605882e-15 + dpu0n3 a0=0.8771189
+ la0=-7.1350570e-08 wa0=1.2410786e-07 pa0=-3.6596080e-14
+ keta=-5.3992410e-02 lketa=7.5446550e-09 wketa=-4.2032270e-08
+ pketa=1.8997448e-14 a1=0.00 a2=0.9900000
+ ags=-2.0000029e-02 b0=0.00 b1=0.00
+ voff= - 0.1004960 + dvoffn3
+ lvoff= - 3.7645670e-09 + dlvoffn3
+ wvoff= - 4.5400990e-09 + dwvoffn3
+ pvoff=5.8367300e-15 + dpvoffn3
+ nfactor=1.0000000 + dnfactorn3 pnfactor=0 + dpnfactorn3
+ wnfactor=0 + dwnfactorn3 lnfactor=0 + dlnfactorn3
+ cit=4.8816460e-04 lcit=6.6214410e-12 wcit=3.0312121e-11
+ pcit=-1.0693267e-17 cdsc=0.00 cdscb=0.00
+ cdscd=0.00 eta0= - 1.1666667e-03 + deta0n3
+ peta0=0 + dpeta0n3 weta0=0 + dweta0n3
+ leta0=6.6666660e-10 + dleta0n3 etab=3.7764110e-03
+ letab=-1.7105642e-09 wetab=-1.1034047e-09 petab=4.4136180e-16
+ dsub=0.00 pclm=-0.2024819 lpclm=3.5845730e-07
+ wpclm=5.9620970e-07 ppclm=-1.3638029e-13 pdiblc1=1.0000000e-06
+ pdiblc2=-1.1344876e-02 lpdiblc2=4.9349870e-09 wpdiblc2=6.8173790e-09
+ ppdiblc2=-2.6974037e-15 pdiblcb=1.0000000e-02 drout=0.00
+ pscbe1=3.5000020e08 pscbe2=1.0000000e-06 pvag=0.00
+ delta=1.0000000e-02 alpha0=0.0 alpha1=7.049416
+ beta0=21.5673 kt1=-0.2558013 lkt1=-1.7826350e-09
+ wkt1=-1.3100086e-07 pkt1=4.2649530e-14 kt2=-1.8057920e-02
+ lkt2=-1.6622183e-09 wkt2=1.0027706e-09 pkt2=-2.7101770e-15
+ at=2.0123486e04 lat=-4.9394840e-05 wat=-1.2311670e-03
+ pat=4.9246680e-10 ute=-1.0240370 lute=-9.5193410e-09
+ wute=1.8708050e-07 pute=-1.6398275e-13 ua1=2.0380289e-09
+ lua1=7.8843000e-19 wua1=1.9651618e-17 pua1=-7.8606470e-24
+ ub1=-1.5444776e-18 lub1=1.6075813e-25 wub1=-5.8817450e-25
+ pub1=-9.0092720e-32 uc1=1.0033722e-10 luc1=1.4186265e-17
+ wuc1=-9.6220470e-17 puc1=-8.2396960e-24 kt1l=0.00
+ prt=0 cj=cjn3 pb=0.7076023
+ mj=0.3259624 cjsw=cjswn3 pbsw=0.7076023
+ mjsw=0.1513672 cjswg=cjswgn3 pbswg=0.7076023
+ mjswg=0.3513672 cgdo=cgon3 cgso=cgon3
+ tcj=0.0009923959 tcjsw=0.0005019466 tcjswg=0.0005019466
+ tpb=0.001687207 tpbsw=0.001687207 tpbswg=0.001687207
+ js=3.93e-07 jsw=1.43e-12 n=1
+ xti=3 capmod=3 nqsmod=0
+ xpart=1 cf=0 tlev=1
+ tlevc=1
+ llc=-0.0165 noimod=2 noia=1.0e20
+ noib=4.0e04 noic=-4.0e-13 em=3.0e07
+ ef=0.881
+ minr=1e-60 imax=0.01 imelt=0.01

 9: type=n
+ lmin=1.000e-05 - dxln3 lmax=20.001e-006 wmin=5.0000e-07 - dxwn3
+ wmax=1.2000e-06 - dxwn3 tnom=25.0 version=3.24
+ tox=toxn3 toxm=6.8e-09 xj=1.7000001e-07
+ nch=5.2600000e17 lln=-1 lwn=1.0000000
+ wln=1.0000000 wwn=1.0000000 lint=4.0000000e-08
+ ll=0.00 lw=0.00 lwl=0.00
+ wint=1.4999999e-08 wl=0.00 ww=0.00
+ wwl=0.00 mobmod=1 binunit=2
+ xl= - 0.02e-6 + dxln3 xw=0.0 + dxwn3 dwg=0.00
+ dwb=0.00 ldif=9.00e-08
+ hdif=hdifn3 rsh=rshn3 rd=0
+ rs=0 vth0=0.7453005 + dvthn3 pvth0=0 + dpvthn3
+ lvth0=0 + dlvthn3 wvth0= - 5.3112130e-09 + dwvthn3
+ k1=0.8604288 wk1=7.1317190e-10 k2=3.3322110e-02 + dk2n3
+ lk2=0 + dlk2n3 wk2=7.9219850e-12 k3=0.00
+ dvt0=0.00 dvt1=0.00 dvt2=0.00
+ dvt0w=0.00 dvt1w=0.00 dvt2w=0.00
+ nlx=0.00 w0=0.00 k3b=0.00
+ vsat=1.0000000e05 + dvsatn3 wvsat=0 + dwvsatn3
+ ua=-6.8333380e-10 wua=2.0756087e-17 ub=2.1833304e-18
+ wub=-1.2117484e-25 uc=9.6601420e-11 wuc=-1.0976857e-17
+ rdsw=5.4500000e02 prwb=0.00 prwg=0.00
+ wr=1.0000000 u0=3.7005090e-02 + du0n3
+ pu0=0 + dpu0n3 lu0=0 + dlu0n3
+ wu0=1.2482622e-09 + dwu0n3 a0=0.6158070
+ wa0=1.4977592e-08 keta=1.0741917e-02 wketa=-6.9461940e-10
+ a1=0.00 a2=0.9900000 ags=2.0000000e-02
+ b0=0.00 b1=0.00
+ voff= - 0.1248287 + dvoffn3 pvoff=0 + dpvoffn3
+ lvoff=0 + dlvoffn3 wvoff= - 9.6051810e-10 + dwvoffn3
+ nfactor=1.0000000 + dnfactorn3 pnfactor=0 + dpnfactorn3
+ wnfactor=0 + dwnfactorn3 lnfactor=0 + dlnfactorn3
+ cit=1.9465643e-04 wcit=1.4539148e-10 cdsc=0.00
+ cdscb=0.00 cdscd=0.00
+ eta0=1.0000000e-05 + deta0n3 peta0=0 + dpeta0n3
+ weta0=0 + dweta0n3 leta0=0 + dleta0n3 etab=-1.0000000e-05
+ dsub=0.00 pclm=0.5000000 pdiblc1=1.0000000e-06
+ pdiblc2=5.0000000e-04 pdiblcb=1.0000000e-02 drout=0.00
+ pscbe1=2.0000000e08 pscbe2=1.0000000e-06 pvag=0.00
+ delta=1.0000000e-02 alpha0=0.0 alpha1=7.049416
+ beta0=21.5673 kt1=-0.3068818 wkt1=5.2137960e-09
+ kt2=-3.1908540e-02 wkt2=1.2880030e-09 at=2.0000000e04
+ ute=-1.3297856 wute=2.5757439e-08 ua1=2.0399999e-09
+ ub1=-2.2946240e-18 wub1=-4.9335480e-26 uc1=-4.8472800e-11
+ wuc1=-1.9522108e-17 kt1l=0.00 prt=0
+ cj=cjn3 pb=0.7076023 mj=0.3259624
+ cjsw=cjswn3 pbsw=0.7076023 mjsw=0.1513672
+ cjswg=cjswgn3 pbswg=0.7076023 mjswg=0.3513672
+ cgdo=cgon3 cgso=cgon3 tcj=0.0009923959
+ tcjsw=0.0005019466 tcjswg=0.0005019466 tpb=0.001687207
+ tpbsw=0.001687207 tpbswg=0.001687207 js=3.93e-07
+ jsw=1.43e-12 n=1 xti=3
+ capmod=3 nqsmod=0 xpart=1
+ cf=0 tlev=1 tlevc=1
+ llc=-0.0165
+ noimod=2 noia=1.0e20 noib=4.0e04
+ noic=-4.0e-13 em=3.0e07 ef=0.881
+ minr=1e-60 imax=0.01 imelt=0.01

 10: type=n
+ lmin=1.200e-06 - dxln3 lmax=1.000e-05 - dxln3 wmin=5.0000e-07 - dxwn3
+ wmax=1.2000e-06 - dxwn3 tnom=25.0 version=3.24
+ tox=toxn3 toxm=6.8e-09 xj=1.7000001e-07
+ nch=5.2600000e17 lln=-1 lwn=1.0000000
+ wln=1.0000000 wwn=1.0000000 lint=4.0000000e-08
+ ll=0.00 lw=0.00 lwl=0.00
+ wint=1.4999999e-08 wl=0.00 ww=0.00
+ wwl=0.00 mobmod=1 binunit=2
+ xl= - 0.02e-6 + dxln3 xw=0.0 + dxwn3 dwg=0.00
+ dwb=0.00 ldif=9.00e-08
+ hdif=hdifn3 rsh=rshn3 rd=0
+ rs=0 vth0=0.7392390 + dvthn3
+ lvth0=6.0008470e-08 + dlvthn3
+ wvth0= - 4.8123240e-09 + dwvthn3
+ pvth0= - 4.9390020e-15 + dpvthn3 k1=0.8554150
+ lk1=4.9636120e-08 wk1=1.0075173e-09 pk1=-2.9140208e-15
+ k2=3.5897850e-02 + dk2n3
+ lk2= - 2.5499832e-08 + dlk2n3 wk2=1.6827269e-11
+ pk2=-8.8160490e-17 k3=0.00 dvt0=0.00
+ dvt1=0.00 dvt2=0.00 dvt0w=0.00
+ dvt1w=0.00 dvt2w=0.00 nlx=0.00
+ w0=0.00 k3b=0.00
+ vsat=1.0087500e05 + dvsatn3 wvsat=0 + dwvsatn3
+ lvsat=-8.6625000e-03 ua=-6.8346730e-10 lua=1.3221220e-18
+ wua=2.2076628e-17 pua=-1.3073367e-23 ub=2.1908280e-18
+ lub=-7.4224610e-26 wub=-1.2010437e-25 pub=-1.0597751e-32
+ uc=9.5323490e-11 luc=1.2651537e-17 wuc=-1.0341395e-17
+ puc=-6.2910760e-24 rdsw=5.4500000e02 prwb=0.00
+ prwg=0.00 wr=1.0000000 u0=3.6837630e-02 + du0n3
+ lu0=1.6578280e-09 + dlu0n3
+ wu0=1.2716347e-09 + dwu0n3
+ pu0= - 2.3138870e-16 + dpu0n3 a0=0.6236824
+ la0=-7.7966580e-08 wa0=1.7982831e-08 pa0=-2.9751866e-14
+ keta=1.3718577e-02 lketa=-2.9468925e-08 wketa=-1.1344492e-09
+ pketa=4.3543190e-15 a1=0.00 a2=0.9900000
+ ags=2.0000000e-02 b0=0.00 b1=0.00
+ voff= - 0.1265495 + dvoffn3
+ lvoff=1.7036285e-08 + dlvoffn3
+ wvoff= - 7.8502870e-10 + dwvoffn3
+ pvoff= - 1.7373450e-15 + dpvoffn3
+ nfactor=1.0000000 + dnfactorn3 pnfactor=0 + dpnfactorn3
+ wnfactor=0 + dwnfactorn3 lnfactor=0 + dlnfactorn3
+ cit=1.5283188e-04 lcit=4.1406270e-10 wcit=1.6504902e-10
+ pcit=-1.9460947e-16 cdsc=0.00 cdscb=0.00
+ cdscd=0.00 eta0=1.0000000e-05 + deta0n3
+ peta0=0 + dpeta0n3 weta0=0 + dweta0n3 leta0=0 + dleta0n3
+ etab=-1.0000000e-05 dsub=0.00 pclm=0.4768089
+ lpclm=2.2959227e-07 wpclm=-4.9807780e-09 ppclm=4.9309700e-14
+ pdiblc1=1.0000000e-06 pdiblc2=4.3750000e-04 lpdiblc2=6.1875000e-10
+ pdiblcb=1.0000000e-02 drout=0.00 pscbe1=1.8500000e08
+ lpscbe1=1.4850000e02 pscbe2=1.0000000e-06 pvag=0.00
+ delta=1.0000000e-02 alpha0=0.0 alpha1=7.049416
+ beta0=21.5673 kt1=-0.3090271 lkt1=2.1238611e-08
+ wkt1=6.0080370e-09 pkt1=-7.8629890e-15 kt2=-3.2233010e-02
+ lkt2=3.2122820e-09 wkt2=1.3803272e-09 pkt2=-9.1400860e-16
+ at=2.0000000e04 ute=-1.3385403 lute=8.6671380e-08
+ wute=2.8228550e-08 pute=-2.4463984e-14 ua1=2.0399999e-09
+ ub1=-2.3244689e-18 lub1=2.9546524e-25 wub1=-5.1586550e-26
+ pub1=2.2285513e-32 uc1=-5.3462490e-11 luc1=4.9397990e-17
+ wuc1=-2.0926594e-17 puc1=1.3904406e-23 kt1l=0.00
+ prt=0 cj=cjn3 pb=0.7076023
+ mj=0.3259624 cjsw=cjswn3 pbsw=0.7076023
+ mjsw=0.1513672 cjswg=cjswgn3 pbswg=0.7076023
+ mjswg=0.3513672 cgdo=cgon3 cgso=cgon3
+ tcj=0.0009923959 tcjsw=0.0005019466 tcjswg=0.0005019466
+ tpb=0.001687207 tpbsw=0.001687207 tpbswg=0.001687207
+ js=3.93e-07 jsw=1.43e-12 n=1
+ xti=3 capmod=3 nqsmod=0
+ xpart=1 cf=0 tlev=1
+ tlevc=1
+ llc=-0.0165 noimod=2 noia=1.0e20
+ noib=4.0e04 noic=-4.0e-13 em=3.0e07
+ ef=0.881
+ minr=1e-60 imax=0.01 imelt=0.01

 11: type=n
+ lmin=5.000e-07 - dxln3 lmax=1.200e-06 - dxln3 wmin=5.0000e-07 - dxwn3
+ wmax=1.2000e-06 - dxwn3 tnom=25.0 version=3.24
+ tox=toxn3 toxm=6.8e-09 xj=1.7000001e-07
+ nch=5.2600000e17 lln=-1 lwn=1.0000000
+ wln=1.0000000 wwn=1.0000000 lint=4.0000000e-08
+ ll=0.00 lw=0.00 lwl=0.00
+ wint=1.4999999e-08 wl=0.00 ww=0.00
+ wwl=0.00 mobmod=1 binunit=2
+ xl= - 0.02e-6 + dxln3 xw=0.0 + dxwn3 dwg=0.00
+ dwb=0.00 ldif=9.00e-08
+ hdif=hdifn3 rsh=rshn3 rd=0
+ rs=0 vth0=0.7679389 + dvthn3
+ lvth0=2.8438597e-08 + dlvthn3
+ wvth0= - 3.5970320e-09 + dwvthn3
+ pvth0= - 6.2758240e-15 + dpvthn3 k1=0.8724138
+ lk1=3.0937503e-08 wk1=-1.3823059e-08 pk1=1.3399614e-14
+ k2=2.7055200e-02 + dk2n3
+ lk2= - 1.5772912e-08 + dlk2n3 wk2=7.1020800e-09
+ pk2=-7.8819390e-15 k3=0.00 dvt0=0.00
+ dvt1=0.00 dvt2=0.00 dvt0w=0.00
+ dvt1w=0.00 dvt2w=0.00 nlx=0.00
+ w0=0.00 k3b=0.00
+ vsat=9.4142860e04 + dvsatn3 wvsat=0 + dwvsatn3
+ lvsat=-1.2571429e-03 ua=-5.2107010e-10 lua=-1.7731486e-16
+ wua=-1.9205736e-17 pua=3.2337230e-23 ub=1.9324246e-18
+ lub=2.1001913e-25 wub=-2.5320272e-26 pub=-1.1486027e-31
+ uc=7.7848640e-11 luc=3.1873880e-17 wuc=-3.9567560e-18
+ puc=-1.3314180e-23 rdsw=5.4500000e02 prwb=0.00
+ prwg=0.00 wr=1.0000000 u0=3.6962610e-02 + du0n3
+ lu0=1.5203439e-09 + dlu0n3
+ wu0=1.0129666e-09 + dwu0n3
+ pu0=5.3146080e-17 + dpu0n3 a0=0.4526256
+ la0=1.1019587e-07 wa0=-1.3244798e-08 pa0=4.5985210e-15
+ keta=1.3228342e-03 lketa=-1.5833610e-08 wketa=-7.7593030e-10
+ pketa=3.9599480e-15 a1=0.00 a2=0.9900000
+ ags=4.2857150e-02 lags=-2.5142864e-08 b0=0.00
+ b1=0.00 voff= - 0.1177271 + dvoffn3
+ lvoff=7.3315800e-09 + dlvoffn3
+ wvoff= - 2.4331537e-09 + dwvoffn3
+ pvoff=7.5592520e-17 + dpvoffn3
+ nfactor=1.0000000 + dnfactorn3 pnfactor=0 + dpnfactorn3
+ wnfactor=0 + dwnfactorn3 lnfactor=0 + dlnfactorn3
+ cit=5.4556720e-04 lcit=-1.7946093e-11 wcit=-2.3381097e-11
+ pcit=1.2663624e-17 cdsc=0.00 cdscb=0.00
+ cdscd=0.00 eta0= - 2.6999993e-04 + deta0n3
+ peta0=0 + dpeta0n3 weta0=0 + dweta0n3
+ leta0=3.0799999e-10 + dleta0n3 etab=2.6999993e-04
+ letab=-3.0799999e-10 dsub=0.00 pclm=0.6877513
+ lpclm=-2.4444284e-09 wpclm=-9.1283720e-08 ppclm=1.4424296e-13
+ pdiblc1=1.0000000e-06 pdiblc2=1.3304478e-03 lpdiblc2=-3.6349270e-10
+ wpdiblc2=-4.2388190e-10 ppdiblc2=4.6627010e-16 pdiblcb=1.0000000e-02
+ drout=0.00 pscbe1=3.0285712e08 lpscbe1=18.8571820
+ pscbe2=1.0000000e-06 pvag=0.00 delta=1.0000000e-02
+ alpha0=0.0 alpha1=7.049416 beta0=21.5673
+ kt1=-0.2803507 lkt1=-1.0305442e-08 wkt1=-1.8520229e-08
+ pkt1=1.9118106e-14 kt2=-2.7456122e-02 lkt2=-2.0422997e-09
+ wkt2=-2.7566189e-09 pkt2=3.6366320e-15 at=2.0000000e04
+ ute=-1.2687004 lute=9.8474450e-09 wute=5.5637800e-09
+ pute=4.6726310e-16 ua1=2.0399999e-09 ub1=-2.1894782e-18
+ lub1=1.4697553e-25 wub1=-3.8690170e-26 pub1=8.0994940e-33
+ uc1=-3.5313570e-11 luc1=2.9434180e-17 wuc1=-1.1473530e-17
+ puc1=3.5060390e-24 kt1l=0.00 prt=0
+ cj=cjn3 pb=0.7076023 mj=0.3259624
+ cjsw=cjswn3 pbsw=0.7076023 mjsw=0.1513672
+ cjswg=cjswgn3 pbswg=0.7076023 mjswg=0.3513672
+ cgdo=cgon3 cgso=cgon3 tcj=0.0009923959
+ tcjsw=0.0005019466 tcjswg=0.0005019466 tpb=0.001687207
+ tpbsw=0.001687207 tpbswg=0.001687207 js=3.93e-07
+ jsw=1.43e-12 n=1 xti=3
+ capmod=3 nqsmod=0 xpart=1
+ cf=0 tlev=1 tlevc=1
+ llc=-0.0165
+ noimod=2 noia=1.0e20 noib=4.0e04
+ noic=-4.0e-13 em=3.0e07 ef=0.881
+ minr=1e-60 imax=0.01 imelt=0.01

 12: type=n
+ lmin=3.5e-007 lmax=5.000e-07 - dxln3 wmin=5.0000e-07 - dxwn3
+ wmax=1.2000e-06 - dxwn3 tnom=25.0 version=3.24
+ tox=toxn3 toxm=6.8e-09 xj=1.7000001e-07
+ nch=5.2600000e17 lln=-1 lwn=1.0000000
+ wln=1.0000000 wwn=1.0000000 lint=4.0000000e-08
+ ll=0.00 lw=0.00 lwl=0.00
+ wint=1.4999999e-08 wl=0.00 ww=0.00
+ wwl=0.00 mobmod=1 binunit=2
+ xl= - 0.02e-6 + dxln3 xw=0.0 + dxwn3 dwg=0.00
+ dwb=0.00 ldif=9.00e-08
+ hdif=hdifn3 rsh=rshn3 rd=0
+ rs=0 vth0=0.9005772 + dvthn3
+ lvth0= - 2.4616741e-08 + dlvthn3
+ wvth0= - 4.3511230e-08 + dwvthn3
+ pvth0=9.6898540e-15 + dpvthn3 k1=0.6045249
+ lk1=1.3809307e-07 wk1=8.1591280e-08 pk1=-2.4766122e-14
+ k2=0.2179352 + dk2n3 lk2= - 9.2124900e-08 + dlk2n3
+ wk2=-2.7927635e-08 pk2=6.1299460e-15 k3=0.00
+ dvt0=0.00 dvt1=0.00 dvt2=0.00
+ dvt0w=0.00 dvt1w=0.00 dvt2w=0.00
+ nlx=0.00 w0=0.00 k3b=0.00
+ vsat=9.2204430e04 + dvsatn3 lvsat=-4.8177310e-04
+ wvsat= - 3.5765190e-03 + dwvsatn3 pvsat=1.4306075e-09
+ ua=-1.5704804e-09 lua=2.4244926e-16 wua=1.2133967e-16
+ pua=-2.3880921e-23 ub=2.4269640e-18 lub=1.2203315e-26
+ wub=1.5658978e-25 pub=-1.8762427e-31 uc=1.6513216e-10
+ luc=-3.0395374e-18 wuc=-6.6537900e-19 puc=-1.4630729e-23
+ rdsw=5.4500000e02 prwb=0.00 prwg=0.00
+ wr=1.0000000 u0=3.7385670e-02 + du0n3
+ lu0=1.3511215e-09 + dlu0n3
+ wu0= - 2.4402242e-09 + dwu0n3
+ pu0=1.4344223e-15 + dpu0n3 a0=0.8126235
+ la0=-3.3803300e-08 wa0=1.9956742e-07 pa0=-8.0526360e-14
+ keta=-0.1224256 lketa=3.3665760e-08 wketa=3.8034560e-08
+ pketa=-1.1564247e-14 a1=0.00 a2=0.9900000
+ ags=-1.6226115e-02 lags=-1.5095589e-09 wags=-4.4154800e-09
+ pags=1.7661922e-15 b0=0.00 b1=0.00
+ voff= - 9.9843290e-02 + dvoffn3
+ lvoff=1.7806077e-10 + dlvoffn3
+ wvoff= - 5.3038090e-09 + dwvoffn3
+ pvoff=1.2238547e-15 + dpvoffn3
+ nfactor=1.0000000 + dnfactorn3 pnfactor=0 + dpnfactorn3
+ wnfactor=0 + dwnfactorn3 lnfactor=0 + dlnfactorn3
+ cit=4.9520520e-04 lcit=2.1987145e-12 wcit=2.2074649e-11
+ pcit=-5.5186740e-18 cdsc=0.00 cdscb=0.00
+ cdscd=0.00 eta0= - 1.1666662e-03 + deta0n3
+ peta0=0 + dpeta0n3 weta0=0 + dweta0n3
+ leta0=6.6666650e-10 + dleta0n3 etab=2.8333291e-03
+ letab=-1.3333316e-09 dsub=0.00 pclm=-4.2756410e-02
+ lpclm=2.8975865e-07 wpclm=4.0933080e-07 ppclm=-5.6002840e-14
+ pdiblc1=1.0000000e-06 pdiblc2=-7.2087520e-03 lpdiblc2=3.0521874e-09
+ wpdiblc2=1.9781137e-09 ppdiblc2=-4.9452820e-16 pdiblcb=1.0000000e-02
+ drout=0.00 pscbe1=3.5000020e08 pscbe2=1.0000000e-06
+ pvag=0.00 delta=1.0000000e-02 alpha0=0.0
+ alpha1=7.049416 beta0=21.5673 kt1=-0.4885682
+ lkt1=7.2981510e-08 wkt1=1.4133636e-07 pkt1=-4.4824520e-14
+ kt2=-2.8753173e-02 lkt2=-1.5234798e-09 wkt2=1.3516213e-08
+ pkt2=-2.8725001e-15 at=3.0581551e04 lat=-4.2326190e-03
+ wat=-1.3467096e-02 pat=5.3868380e-09 ute=-0.7753763
+ lute=-1.8748216e-07 wute=-1.0385240e-07 pute=4.4233730e-14
+ ua1=1.7494718e-09 lua1=1.1621127e-16 wua1=3.5726330e-16
+ pua1=-1.4290532e-22 ub1=-1.3971897e-18 lub1=-1.6993981e-25
+ wub1=-7.6050110e-25 pub1=2.9682384e-31 uc1=6.9721260e-11
+ luc1=-1.2579750e-17 wuc1=-6.0399780e-17 puc1=2.3076537e-23
+ kt1l=0.00 prt=0 cj=cjn3
+ pb=0.7076023 mj=0.3259624 cjsw=cjswn3
+ pbsw=0.7076023 mjsw=0.1513672 cjswg=cjswgn3
+ pbswg=0.7076023 mjswg=0.3513672 cgdo=cgon3
+ cgso=cgon3 tcj=0.0009923959 tcjsw=0.0005019466
+ tcjswg=0.0005019466 tpb=0.001687207 tpbsw=0.001687207
+ tpbswg=0.001687207 js=3.93e-07 jsw=1.43e-12
+ n=1 xti=3 capmod=3
+ nqsmod=0 xpart=1 cf=0
+ tlev=1 tlevc=1
+ llc=-0.0165 noimod=2
+ noia=1.0e20 noib=4.0e04 noic=-4.0e-13
+ em=3.0e07 ef=0.881
+ minr=1e-60 imax=0.01 imelt=0.01

 13: type=n
+ lmin=1.000e-05 - dxln3 lmax=20.001e-006 wmin=2.2e-007
+ wmax=5.0000e-07 - dxwn3 tnom=25.0 version=3.24
+ tox=toxn3 toxm=6.8e-09 xj=1.7000001e-07
+ nch=5.2600000e17 lln=-1 lwn=1.0000000
+ wln=1.0000000 wwn=1.0000000 lint=4.0000000e-08
+ ll=0.00 lw=0.00 lwl=0.00
+ wint=1.4999999e-08 wl=0.00 ww=0.00
+ wwl=0.00 mobmod=1 binunit=2
+ xl= - 0.02e-6 + dxln3 xw=0.0 + dxwn3 dwg=0.00
+ dwb=0.00 ldif=9.00e-08
+ hdif=hdifn3 rsh=rshn3 rd=0
+ rs=0 vth0=0.7828572 + dvthn3 pvth0=0 + dpvthn3
+ lvth0=0 + dlvthn3 wvth0= - 2.2962862e-08 + dwvthn3
+ k1=0.8670291 wk1=-2.3889963e-09 k2=3.3539240e-02 + dk2n3
+ lk2=0 + dlk2n3 wk2=-9.4124950e-11 k3=0.00
+ dvt0=0.00 dvt1=0.00 dvt2=0.00
+ dvt0w=0.00 dvt1w=0.00 dvt2w=0.00
+ nlx=0.00 w0=0.00 k3b=0.00
+ vsat=1.0000000e05 + dvsatn3 wvsat=0 + dwvsatn3
+ ua=-7.5109630e-10 wua=5.2604480e-17 ub=2.0614427e-18
+ wub=-6.3887530e-26 uc=9.9038940e-11 wuc=-1.2122493e-17
+ rdsw=5.4500000e02 prwb=0.00 prwg=0.00
+ wr=1.0000000 u0=3.6716620e-02 + du0n3
+ pu0=0 + dpu0n3 lu0=0 + dlu0n3
+ wu0=1.3838430e-09 + dwu0n3 a0=0.6640292
+ wa0=-7.6868640e-09 keta=1.4611328e-02 wketa=-2.5132423e-09
+ a1=0.00 a2=0.9900000 ags=2.0000000e-02
+ b0=0.00 b1=0.00
+ voff= - 0.1274730 + dvoffn3 pvoff=0 + dpvoffn3
+ lvoff=0 + dlvoffn3 wvoff=2.8231190e-10 + dwvoffn3
+ nfactor=1.0000000 + dnfactorn3 pnfactor=0 + dpnfactorn3
+ wnfactor=0 + dwnfactorn3 lnfactor=0 + dlnfactorn3
+ cit=5.0400000e-04 cdsc=0.00 cdscb=0.00
+ cdscd=0.00 eta0=1.0000000e-05 + deta0n3
+ peta0=0 + dpeta0n3 weta0=0 + dweta0n3 leta0=0 + dleta0n3
+ etab=-1.0000000e-05 dsub=0.00 pclm=0.5000000
+ pdiblc1=1.0000000e-06 pdiblc2=5.0000000e-04 pdiblcb=1.0000000e-02
+ drout=0.00 pscbe1=2.0000000e08 pscbe2=1.0000000e-06
+ pvag=0.00 delta=1.0000000e-02 alpha0=0.0
+ alpha1=7.049416 beta0=21.5673 kt1=-0.2971856
+ wkt1=6.5657340e-10 kt2=-2.7439827e-02 wkt2=-8.1229250e-10
+ at=2.0000000e04 ute=-1.2430322 wute=-1.5016651e-08
+ ua1=2.0399999e-09 ub1=-2.1566485e-18 wub1=-1.1418396e-25
+ uc1=-5.2926640e-11 wuc1=-1.7428805e-17 kt1l=0.00
+ prt=0 cj=cjn3 pb=0.7076023
+ mj=0.3259624 cjsw=cjswn3 pbsw=0.7076023
+ mjsw=0.1513672 cjswg=cjswgn3 pbswg=0.7076023
+ mjswg=0.3513672 cgdo=cgon3 cgso=cgon3
+ tcj=0.0009923959 tcjsw=0.0005019466 tcjswg=0.0005019466
+ tpb=0.001687207 tpbsw=0.001687207 tpbswg=0.001687207
+ js=3.93e-07 jsw=1.43e-12 n=1
+ xti=3 capmod=3 nqsmod=0
+ xpart=1 cf=0 tlev=1
+ tlevc=1
+ llc=-0.0165 noimod=2 noia=1.0e20
+ noib=4.0e04 noic=-4.0e-13 em=3.0e07
+ ef=0.881
+ minr=1e-60 imax=0.01 imelt=0.01

 14: type=n
+ lmin=1.200e-06 - dxln3 lmax=1.000e-05 - dxln3 wmin=2.2e-007
+ wmax=5.0000e-07 - dxwn3 tnom=25.0 version=3.24
+ tox=toxn3 toxm=6.8e-09 xj=1.7000001e-07
+ nch=5.2600000e17 lln=-1 lwn=1.0000000
+ wln=1.0000000 wwn=1.0000000 lint=4.0000000e-08
+ ll=0.00 lw=0.00 lwl=0.00
+ wint=1.4999999e-08 wl=0.00 ww=0.00
+ wwl=0.00 mobmod=1 binunit=2
+ xl= - 0.02e-6 + dxln3 xw=0.0 + dxwn3 dwg=0.00
+ dwb=0.00 ldif=9.00e-08
+ hdif=hdifn3 rsh=rshn3 rd=0
+ rs=0 vth0=0.7804866 + dvthn3
+ lvth0=2.3468242e-08 + dlvthn3
+ wvth0= - 2.4198712e-08 + dwvthn3
+ pvth0=1.2234904e-14 + dpvthn3 k1=0.8636016
+ lk1=3.3932720e-08 wk1=-2.8401654e-09 pk1=4.4665790e-15
+ k2=3.5084160e-02 + dk2n3
+ lk2= - 1.5294709e-08 + dlk2n3 wk2=3.9926540e-10
+ pk2=-4.8845690e-15 k3=0.00 dvt0=0.00
+ dvt1=0.00 dvt2=0.00 dvt0w=0.00
+ dvt1w=0.00 dvt2w=0.00 nlx=0.00
+ w0=0.00 k3b=0.00
+ vsat=1.0087500e05 + dvsatn3 wvsat=0 + dwvsatn3
+ lvsat=-8.6625000e-03 ua=-7.5848670e-10 lua=7.3164600e-17
+ wua=5.7335730e-17 pua=-4.6839330e-23 ub=2.0926081e-18
+ lub=-3.0854041e-25 wub=-7.3941130e-26 pub=9.9530690e-32
+ uc=1.0056940e-10 luc=-1.5151562e-17 wuc=-1.2806976e-17
+ puc=6.7763810e-24 rdsw=5.4500000e02 prwb=0.00
+ prwg=0.00 wr=1.0000000 u0=3.7054640e-02 + du0n3
+ lu0= - 3.3465050e-09 + dlu0n3
+ wu0=1.1696366e-09 + dwu0n3
+ pu0=2.1206480e-15 + dpu0n3 a0=0.6665249
+ la0=-2.4707576e-08 wa0=-2.1531732e-09 pa0=-5.4783600e-14
+ keta=1.5772361e-02 lketa=-1.1494187e-08 wketa=-2.0997273e-09
+ pketa=-4.0938080e-15 a1=0.00 a2=0.9900000
+ ags=2.0000000e-02 b0=0.00 b1=0.00
+ voff= - 0.1297337 + dvoffn3
+ lvoff=2.2381130e-08 + dlvoffn3
+ wvoff=7.1154630e-10 + dwvoffn3
+ pvoff= - 4.2494230e-15 + dpvoffn3
+ nfactor=1.0000000 + dnfactorn3 pnfactor=0 + dpnfactorn3
+ wnfactor=0 + dwnfactorn3 lnfactor=0 + dlnfactorn3
+ cit=5.0400000e-04 cdsc=0.00 cdscb=0.00
+ cdscd=0.00 eta0=1.0000000e-05 + deta0n3
+ peta0=0 + dpeta0n3 weta0=0 + dweta0n3 leta0=0 + dleta0n3
+ etab=-1.0000000e-05 dsub=0.00 pclm=0.4717489
+ lpclm=2.7968576e-07 wpclm=-2.6026028e-09 ppclm=2.5765768e-14
+ pdiblc1=1.0000000e-06 pdiblc2=4.3750000e-04 lpdiblc2=6.1874990e-10
+ pdiblcb=1.0000000e-02 drout=0.00 pscbe1=1.8500000e08
+ lpscbe1=1.4850000e02 pscbe2=1.0000000e-06 pvag=0.00
+ delta=1.0000000e-02 alpha0=0.0 alpha1=7.049416
+ beta0=21.5673 kt1=-0.2951206 lkt1=-2.0443341e-08
+ wkt1=-5.2802380e-10 pkt1=1.1727529e-14 kt2=-2.7106613e-02
+ lkt2=-3.2988250e-09 wkt2=-1.0290813e-09 pkt2=2.1462119e-15
+ at=2.0000000e04 ute=-1.2394767 lute=-3.5199690e-08
+ wute=-1.8331338e-08 pute=3.2815420e-14 ua1=2.0399999e-09
+ ub1=-2.1723405e-18 lub1=1.5535091e-25 wub1=-1.2308690e-25
+ pub1=8.8139250e-32 uc1=-5.9918290e-11 luc1=6.9217410e-17
+ wuc1=-1.7892370e-17 puc1=4.5892800e-24 kt1l=0.00
+ prt=0 cj=cjn3 pb=0.7076023
+ mj=0.3259624 cjsw=cjswn3 pbsw=0.7076023
+ mjsw=0.1513672 cjswg=cjswgn3 pbswg=0.7076023
+ mjswg=0.3513672 cgdo=cgon3 cgso=cgon3
+ tcj=0.0009923959 tcjsw=0.0005019466 tcjswg=0.0005019466
+ tpb=0.001687207 tpbsw=0.001687207 tpbswg=0.001687207
+ js=3.93e-07 jsw=1.43e-12 n=1
+ xti=3 capmod=3 nqsmod=0
+ xpart=1 cf=0 tlev=1
+ tlevc=1
+ llc=-0.0165 noimod=2 noia=1.0e20
+ noib=4.0e04 noic=-4.0e-13 em=3.0e07
+ ef=0.881
+ minr=1e-60 imax=0.01 imelt=0.01

 15: type=n
+ lmin=5.000e-07 - dxln3 lmax=1.200e-06 - dxln3 wmin=2.2e-007
+ wmax=5.0000e-07 - dxwn3 tnom=25.0 version=3.24
+ tox=toxn3 toxm=6.8e-09 xj=1.7000001e-07
+ nch=5.2600000e17 lln=-1 lwn=1.0000000
+ wln=1.0000000 wwn=1.0000000 lint=4.0000000e-08
+ ll=0.00 lw=0.00 lwl=0.00
+ wint=1.4999999e-08 wl=0.00 ww=0.00
+ wwl=0.00 mobmod=1 binunit=2
+ xl= - 0.02e-6 + dxln3 xw=0.0 + dxwn3 dwg=0.00
+ dwb=0.00 ldif=9.00e-08
+ hdif=hdifn3 rsh=rshn3 rd=0
+ rs=0 vth0=0.7807397 + dvthn3
+ lvth0=2.3189909e-08 + dlvthn3
+ wvth0= - 9.6134030e-09 + dwvthn3
+ pvth0= - 3.8089400e-15 + dpvthn3 k1=0.7736582
+ lk1=1.3287044e-07 wk1=3.2592050e-08 pk1=-3.4508860e-14
+ k2=6.4881680e-02 + dk2n3
+ lk2= - 4.8071990e-08 + dlk2n3 wk2=-1.0676364e-08
+ pk2=7.2986250e-15 k3=0.00 dvt0=0.00
+ dvt1=0.00 dvt2=0.00 dvt0w=0.00
+ dvt1w=0.00 dvt2w=0.00 nlx=0.00
+ w0=0.00 k3b=0.00
+ vsat=9.4142860e04 + dvsatn3 wvsat=0 + dwvsatn3
+ lvsat=-1.2571429e-03 ua=-5.9941190e-10 lua=-1.0181772e-16
+ wua=1.7614915e-17 pua=-3.1464334e-24 ub=1.5764261e-18
+ lub=2.5926002e-25 wub=1.4199901e-25 pub=-1.3800350e-31
+ uc=4.5846500e-11 luc=4.5043640e-17 wuc=1.1084252e-17
+ puc=-1.9503975e-23 rdsw=5.4500000e02 prwb=0.00
+ prwg=0.00 wr=1.0000000 u0=3.1034408e-02 + du0n3
+ lu0=3.2757530e-09 + dlu0n3
+ wu0=3.7992220e-09 + dwu0n3
+ pu0= - 7.7189640e-16 + dpu0n3 a0=0.4857765
+ la0=1.7411581e-07 wa0=-2.8825673e-08 pa0=-2.5443860e-14
+ keta=2.5973169e-02 lketa=-2.2715076e-08 wketa=-1.2361587e-08
+ pketa=7.1942380e-15 a1=0.00 a2=0.9900000
+ ags=4.2857150e-02 lags=-2.5142864e-08 b0=0.00
+ b1=0.00 voff= - 0.1085447 + dvoffn3
+ lvoff= - 9.2680400e-10 + dlvoffn3
+ wvoff= - 6.7488680e-09 + dwvoffn3
+ pvoff=3.9570330e-15 + dpvoffn3
+ nfactor=1.0000000 + dnfactorn3 pnfactor=0 + dpnfactorn3
+ wnfactor=0 + dwnfactorn3 lnfactor=0 + dlnfactorn3
+ cit=5.4827290e-04 lcit=-4.8700200e-11 wcit=-2.4652778e-11
+ pcit=2.7118061e-17 cdsc=0.00 cdscb=0.00
+ cdscd=0.00 eta0= - 2.7000002e-04 + deta0n3
+ peta0=0 + dpeta0n3 weta0=0 + dweta0n3
+ leta0=3.0800001e-10 + dleta0n3 etab=2.7000002e-04
+ letab=-3.0800001e-10 dsub=0.00 pclm=0.6242409
+ lpclm=1.1194462e-07 wpclm=-6.1433820e-08 ppclm=9.0480110e-14
+ pdiblc1=1.0000000e-06 pdiblc2=4.2857150e-04 lpdiblc2=6.2857140e-10
+ pdiblcb=1.0000000e-02 drout=0.00 pscbe1=3.0285712e08
+ lpscbe1=18.8571830 pscbe2=1.0000000e-06 pvag=0.00
+ delta=1.0000000e-02 alpha0=0.0 alpha1=7.049416
+ beta0=21.5673 kt1=-0.3598902 lkt1=5.0803170e-08
+ wkt1=1.8863313e-08 pkt1=-9.6029440e-15 kt2=-3.7711450e-02
+ lkt2=8.3664990e-09 wkt2=2.0633864e-09 pkt2=-1.2555028e-15
+ at=2.0000000e04 ute=-1.3677146 lute=1.0586200e-07
+ wute=5.2100470e-08 pute=-4.4659580e-14 ua1=2.0399999e-09
+ ub1=-2.1250930e-18 lub1=1.0337858e-25 wub1=-6.8951290e-26
+ pub1=2.8590071e-32 uc1=-3.6162200e-12 luc1=7.2851270e-18
+ wuc1=-2.6371291e-17 puc1=1.3916098e-23 kt1l=0.00
+ prt=0 cj=cjn3 pb=0.7076023
+ mj=0.3259624 cjsw=cjswn3 pbsw=0.7076023
+ mjsw=0.1513672 cjswg=cjswgn3 pbswg=0.7076023
+ mjswg=0.3513672 cgdo=cgon3 cgso=cgon3
+ tcj=0.0009923959 tcjsw=0.0005019466 tcjswg=0.0005019466
+ tpb=0.001687207 tpbsw=0.001687207 tpbswg=0.001687207
+ js=3.93e-07 jsw=1.43e-12 n=1
+ xti=3 capmod=3 nqsmod=0
+ xpart=1 cf=0 tlev=1
+ tlevc=1
+ llc=-0.0165 noimod=2 noia=1.0e20
+ noib=4.0e04 noic=-4.0e-13 em=3.0e07
+ ef=0.881
+ minr=1e-60 imax=0.01 imelt=0.01

 16: type=n
+ lmin=3.5e-007 lmax=5.000e-07 - dxln3 wmin=2.2e-007
+ wmax=5.0000e-07 - dxwn3 tnom=25.0 version=3.24
+ tox=toxn3 toxm=6.8e-09 xj=1.7000001e-07
+ nch=5.2600000e17 lln=-1 lwn=1.0000000
+ wln=1.0000000 wwn=1.0000000 lint=4.0000000e-08
+ ll=0.00 lw=0.00 lwl=0.00
+ wint=1.4999999e-08 wl=0.00 ww=0.00
+ wwl=0.00 mobmod=1 binunit=2
+ xl= - 0.02e-6 + dxln3 xw=0.0 + dxwn3 dwg=0.00
+ dwb=0.00 ldif=9.00e-08
+ hdif=hdifn3 rsh=rshn3 rd=0
+ rs=0 vth0=0.8306194 + dvthn3
+ lvth0=3.2380310e-09 + dlvthn3
+ wvth0= - 1.0631036e-08 + dwvthn3
+ pvth0= - 3.4018870e-15 + dpvthn3 k1=1.0625753
+ lk1=1.7303593e-08 wk1=-1.3369242e-07 pk1=3.2004920e-14
+ k2=0.1064665 + dk2n3 lk2= - 6.4705920e-08 + dlk2n3
+ wk2=2.4462622e-08 pk2=-6.7569720e-15 k3=0.00
+ dvt0=0.00 dvt1=0.00 dvt2=0.00
+ dvt0w=0.00 dvt1w=0.00 dvt2w=0.00
+ nlx=0.00 w0=0.00 k3b=0.00
+ vsat=9.3605550e04 + dvsatn3 lvsat=-1.0422204e-03
+ wvsat= - 4.2350440e-03 + dwvsatn3 pvsat=1.6940175e-09
+ ua=6.7111770e-11 lua=-3.6842710e-16 wua=-6.4832840e-16
+ pua=2.6323089e-22 ub=1.2076053e-18 lub=4.0678830e-25
+ wub=7.2968810e-25 pub=-3.7307910e-31 uc=1.8743894e-10
+ luc=-1.1593328e-17 wuc=-1.1149585e-17 puc=-1.0610441e-23
+ rdsw=5.4500000e02 prwb=0.00 prwg=0.00
+ wr=1.0000000 u0=5.3736130e-02 + du0n3
+ lu0= - 5.8049360e-09 + dlu0n3
+ wu0= - 1.0124940e-08 + dwu0n3
+ pu0=4.7977680e-15 + dpu0n3 a0=1.0752125
+ la0=-6.1658620e-08 wa0=7.6150530e-08 pa0=-6.7434340e-14
+ keta=-9.2701760e-02 lketa=2.4754891e-08 wketa=2.4064352e-08
+ pketa=-7.3761370e-15 a1=0.00 a2=0.9900000
+ ags=1.0422147e-02 lags=-1.2168864e-08 wags=-1.6940159e-08
+ pags=6.7760640e-15 b0=0.00 b1=0.00
+ voff= - 0.1289647 + dvoffn3
+ lvoff=7.2411770e-09 + dlvoffn3
+ wvoff=8.3832410e-09 + dwvoffn3
+ pvoff= - 2.0958096e-15 + dpvoffn3
+ nfactor=1.0000000 + dnfactorn3 pnfactor=0 + dpnfactorn3
+ wnfactor=0 + dwnfactorn3 lnfactor=0 + dlnfactorn3
+ cit=2.9739301e-04 lcit=5.1651740e-11 wcit=1.1504635e-10
+ pcit=-2.8761589e-17 cdsc=0.00 cdscb=0.00
+ cdscd=0.00 eta0= - 1.1666659e-03 + deta0n3
+ peta0=0 + dpeta0n3 weta0=0 + dweta0n3
+ leta0=6.6666640e-10 + dleta0n3 etab=2.8333315e-03
+ letab=-1.3333327e-09 dsub=0.00 pclm=0.5943905
+ lpclm=1.2388473e-07 wpclm=1.0987172e-07 ppclm=2.1957893e-14
+ pdiblc1=1.0000000e-06 pdiblc2=-2.9999996e-03 lpdiblc2=1.9999999e-09
+ pdiblcb=1.0000000e-02 drout=0.00 pscbe1=3.5000020e08
+ pscbe2=1.0000000e-06 pvag=0.00 delta=1.0000000e-02
+ alpha0=0.0 alpha1=7.049416 beta0=21.5673
+ kt1=-0.1415831 lkt1=-3.6519680e-08 wkt1=-2.1746652e-08
+ pkt1=6.6410420e-15 kt2=3.7919310e-03 lkt2=-8.2348550e-09
+ wkt2=-1.7799852e-09 pkt2=2.8184582e-16 at=1.0938882e04
+ lat=3.6244480e-03 wat=-4.2350400e-03 pat=1.6940163e-09
+ ute=-0.9606272 lute=-5.6972970e-08 wute=-1.6784552e-08
+ pute=-1.7105571e-14 ua1=1.2040989e-09 lua1=3.3436030e-16
+ wua1=6.1358830e-16 pua1=-2.4543530e-22 ub1=-5.2839440e-19
+ lub1=-5.3530060e-25 wub1=-1.1688345e-24 pub1=4.6854330e-31
+ uc1=6.8918580e-11 luc1=-2.1728796e-17 wuc1=-6.0022500e-17
+ puc1=2.7376582e-23 kt1l=0.00 prt=0
+ cj=cjn3 pb=0.7076023 mj=0.3259624
+ cjsw=cjswn3 pbsw=0.7076023 mjsw=0.1513672
+ cjswg=cjswgn3 pbswg=0.7076023 mjswg=0.3513672
+ cgdo=cgon3 cgso=cgon3 tcj=0.0009923959
+ tcjsw=0.0005019466 tcjswg=0.0005019466 tpb=0.001687207
+ tpbsw=0.001687207 tpbswg=0.001687207 js=3.93e-07
+ jsw=1.43e-12 n=1 xti=3
+ capmod=3 nqsmod=0 xpart=1
+ cf=0 tlev=1 tlevc=1
+ llc=-0.0165
+ noimod=2 noia=1.0e20 noib=4.0e04
+ noic=-4.0e-13 em=3.0e07 ef=0.881
+ minr=1e-60 imax=0.01 imelt=0.01

//  *****************************************************************************************
//
//             *
//                               3.3V I/O PMOS DEVICE MODELS
//             *
//
//             *
//  *****************************************************************************************

     }
model pch3 bsim3v3  {
 1: type=p
+ lmin=1.000e-05 - dxlp3 lmax=20.001e-006 wmin=1.0000e-05 - dxwp3
+ wmax=900.001e-6 tnom=25.0 version=3.24
+ tox=toxp3 toxm=6.77e-09 xj=1.7000001e-07
+ nch=4.9500000e17 lln=-1 lwn=1.0000000
+ wln=1.0000000 wwn=1.0000000 lint=3.5000000e-08
+ ll=0.00 lw=0.00 lwl=0.00
+ wint=2.0000000e-08 wl=0.00 ww=0.00
+ wwl=0.00 mobmod=1 binunit=2
+ xl= - 0.02e-6 + dxlp3 xw=0.0 + dxwp3 dwg=0.00
+ dwb=0.00 ldif=9.00e-08
+ hdif=hdifp3 rsh=rshp3 rd=0
+ rs=0 vth0= - 0.6977456 + dvthp3
+ pvth0=0 + dpvthp3 wvth0=0 + dwvthp3 lvth0=0 + dlvthp3
+ k1=0.8513944 k2=7.3231060e-02 + dk2p3
+ lk2=0 + dlk2p3 k3=0.00 dvt0=0.00
+ dvt1=0.00 dvt2=0.00 dvt0w=0.00
+ dvt1w=0.00 dvt2w=0.00 nlx=0.00
+ w0=0.00 k3b=0.00
+ vsat=1.5000002e05 + dvsatp3 wvsat=0 + dwvsatp3
+ ua=1.6792380e-09 ub=2.7609050e-19 uc=-1.0631042e-10
+ rdsw=9.0000000e02 prwb=0.00 prwg=0.00
+ wr=1.0000000 u0=1.3079101e-02 + du0p3
+ pu0=0 + dpu0p3 wu0=0 + dwu0p3 lu0=0 + dlu0p3
+ a0=0.9726100 keta=1.9578772e-02 a1=0.00
+ a2=0.9900000 ags=2.0000000e-02 b0=0.00
+ b1=0.00 voff= - 0.1119244 + dvoffp3
+ pvoff=0 + dpvoffp3 wvoff=0 + dwvoffp3 lvoff=0 + dlvoffp3
+ nfactor=1.0000000 + dnfactorp3 pnfactor=0 + dpnfactorp3
+ wnfactor=0 + dwnfactorp3 lnfactor=0 + dlnfactorp3
+ cit=4.5372260e-04 cdsc=0.00 cdscb=0.00
+ cdscd=0.00 eta0=1.0000000e-05 + deta0p3
+ peta0=0 + dpeta0p3 weta0=0 + dweta0p3 leta0=0 + dleta0p3
+ etab=-1.0000000e-05 dsub=0.00 pclm=0.5000001
+ pdiblc1=1.0000000e-06 pdiblc2=1.0000000e-05 pdiblcb=1.0000000e-02
+ drout=0.00 pscbe1=2.0000003e08 pscbe2=5.0000000e-07
+ pvag=0.00 delta=1.0000000e-02 alpha0=0.00
+ alpha1=0.143217238 beta0=16.10832 kt1=-0.2913002
+ kt2=-2.5890822e-02 at=-5.0000000e04 ute=-0.7959498
+ ua1=2.0310000e-09 ub1=-2.6231965e-18 uc1=9.4352360e-12
+ kt1l=0.00 prt=0 cj=cjp3
+ pb=0.8049122 mj=0.3954951 cjsw=cjswp3
+ pbsw=0.8049122 mjsw=0.2573111 cjswg=cjswgp3
+ pbswg=0.8049122 mjswg=0.2573111 cgdo=cgop3
+ cgso=cgop3 tcj=0.0009940197 tcjsw=0.0006908749
+ tcjswg=0.0006908749 tpb=0.001625007 tpbsw=0.001625007
+ tpbswg=0.001625007 js=1.900e-07 jsw=1.00e-12
+ n=1 xti=3 capmod=3
+ nqsmod=0 xpart=1 cf=0
+ tlev=1 tlevc=1
+ llc=-0.0165 noimod=2
+ noia=2.0e19 noib=8.0e03 noic=5.4e-12
+ em=3.0e07 ef=1.094
+ minr=1e-60 imax=0.01 imelt=0.01

 2: type=p
+ lmin=1.200e-06 - dxlp3 lmax=1.000e-05 - dxlp3 wmin=1.0000e-05 - dxwp3
+ wmax=900.001e-6 tnom=25.0 version=3.24
+ tox=toxp3 toxm=6.77e-09 xj=1.7000001e-07
+ nch=4.9500000e17 lln=-1 lwn=1.0000000
+ wln=1.0000000 wwn=1.0000000 lint=3.5000000e-08
+ ll=0.00 lw=0.00 lwl=0.00
+ wint=2.0000000e-08 wl=0.00 ww=0.00
+ wwl=0.00 mobmod=1 binunit=2
+ xl= - 0.02e-6 + dxlp3 xw=0.0 + dxwp3 dwg=0.00
+ dwb=0.00 ldif=9.00e-08
+ hdif=hdifp3 rsh=rshp3 rd=0
+ rs=0 vth0= - 0.6966490 + dvthp3
+ pvth0=0 + dpvthp3 wvth0=0 + dwvthp3
+ lvth0= - 1.0866771e-08 + dlvthp3 k1=0.8495954
+ lk1=1.7827986e-08 k2=7.3845220e-02 + dk2p3
+ lk2= - 6.0863510e-09 + dlk2p3 k3=0.00
+ dvt0=0.00 dvt1=0.00 dvt2=0.00
+ dvt0w=0.00 dvt1w=0.00 dvt2w=0.00
+ nlx=0.00 w0=0.00 k3b=0.00
+ vsat=1.5378411e05 + dvsatp3 wvsat=0 + dwvsatp3
+ lvsat=-3.7500340e-02 ua=1.6902475e-09 lua=-1.0910469e-16
+ ub=2.6840783e-19 lub=7.6135260e-26 uc=-1.0827022e-10
+ luc=1.9421627e-17 rdsw=9.0000000e02 prwb=0.00
+ prwg=0.00 wr=1.0000000 u0=1.3233015e-02 + du0p3
+ pu0=0 + dpu0p3 wu0=0 + dwu0p3
+ lu0= - 1.5252891e-09 + dlu0p3 a0=0.9807407
+ la0=-8.0575180e-08 keta=2.0751586e-02 lketa=-1.1622598e-08
+ a1=0.00 a2=0.9900000 ags=2.0000000e-02
+ b0=0.00 b1=0.00
+ voff= - 0.1119000 + dvoffp3 pvoff=0 + dpvoffp3
+ wvoff=0 + dwvoffp3 lvoff= - 2.4146618e-10 + dlvoffp3
+ nfactor=1.0000000 + dnfactorp3 pnfactor=0 + dpnfactorp3
+ wnfactor=0 + dwnfactorp3 lnfactor=0 + dlnfactorp3
+ cit=4.4763520e-04 lcit=6.0325690e-11 cdsc=0.00
+ cdscb=0.00 cdscd=0.00
+ eta0=1.0000000e-05 + deta0p3 peta0=0 + dpeta0p3
+ weta0=0 + dweta0p3 leta0=0 + dleta0p3 etab=-1.0000000e-05
+ dsub=0.00 pclm=0.4845105 lpclm=1.5350197e-07
+ pdiblc1=1.0000000e-06 pdiblc2=1.0000000e-05 pdiblcb=1.0000000e-02
+ drout=0.00 pscbe1=1.8738642e08 lpscbe1=1.2500109e02
+ pscbe2=5.0000000e-07 pvag=0.00 delta=1.0000000e-02
+ alpha0=0.00 alpha1=0.143217238 beta0=16.10832
+ kt1=-0.2904292 lkt1=-8.6317250e-09 kt2=-2.5863823e-02
+ lkt2=-2.6755742e-10 at=-5.0000000e04 ute=-0.8086896
+ lute=1.2625190e-07 ua1=2.0310000e-09 ub1=-2.6370268e-18
+ lub1=1.3705860e-25 uc1=7.1907790e-12 luc1=2.2242592e-17
+ kt1l=0.00 prt=0 cj=cjp3
+ pb=0.8049122 mj=0.3954951 cjsw=cjswp3
+ pbsw=0.8049122 mjsw=0.2573111 cjswg=cjswgp3
+ pbswg=0.8049122 mjswg=0.2573111 cgdo=cgop3
+ cgso=cgop3 tcj=0.0009940197 tcjsw=0.0006908749
+ tcjswg=0.0006908749 tpb=0.001625007 tpbsw=0.001625007
+ tpbswg=0.001625007 js=1.900e-07 jsw=1.00e-12
+ n=1 xti=3 capmod=3
+ nqsmod=0 xpart=1 cf=0
+ tlev=1 tlevc=1
+ llc=-0.0165 noimod=2
+ noia=2.0e19 noib=8.0e03 noic=5.4e-12
+ em=3.0e07 ef=1.094
+ minr=1e-60 imax=0.01 imelt=0.01

 3: type=p
+ lmin=5.000e-07 - dxlp3 lmax=1.200e-06 - dxlp3 wmin=1.0000e-05 - dxwp3
+ wmax=900.001e-6 tnom=25.0 version=3.24
+ tox=toxp3 toxm=6.77e-09 xj=1.7000001e-07
+ nch=4.9500000e17 lln=-1 lwn=1.0000000
+ wln=1.0000000 wwn=1.0000000 lint=3.5000000e-08
+ ll=0.00 lw=0.00 lwl=0.00
+ wint=2.0000000e-08 wl=0.00 ww=0.00
+ wwl=0.00 mobmod=1 binunit=2
+ xl= - 0.02e-6 + dxlp3 xw=0.0 + dxwp3 dwg=0.00
+ dwb=0.00 ldif=9.00e-08
+ hdif=hdifp3 rsh=rshp3 rd=0
+ rs=0 vth0= - 0.7066531 + dvthp3
+ pvth0=0 + dpvthp3 wvth0=0 + dwvthp3
+ lvth0=2.3770189e-10 + dlvthp3 k1=0.8542004
+ lk1=1.2716471e-08 k2=7.3637170e-02 + dk2p3
+ lk2= - 5.8554080e-09 + dlk2p3 k3=0.00
+ dvt0=0.00 dvt1=0.00 dvt2=0.00
+ dvt0w=0.00 dvt1w=0.00 dvt2w=0.00
+ nlx=0.00 w0=0.00 k3b=0.00
+ vsat=1.2585714e05 + dvsatp3 wvsat=0 + dwvsatp3
+ lvsat=-6.5014080e-03 ua=2.0603699e-09 lua=-5.1994050e-16
+ ub=1.0048677e-19 lub=2.6252766e-25 uc=-1.2948420e-10
+ luc=4.2969150e-17 rdsw=9.0000000e02 prwb=0.00
+ prwg=0.00 wr=1.0000000 u0=1.3020334e-02 + du0p3
+ pu0=0 + dpu0p3 wu0=0 + dwu0p3
+ lu0= - 1.2892131e-09 + dlu0p3 a0=0.8873466
+ la0=2.3092309e-08 keta=2.0400845e-02 lketa=-1.1233276e-08
+ a1=0.00 a2=0.9900000 ags=2.0000000e-02
+ b0=0.00 b1=0.00
+ voff= - 0.1168895 + dvoffp3 pvoff=0 + dpvoffp3
+ wvoff=0 + dwvoffp3 lvoff=5.2969330e-09 + dlvoffp3
+ nfactor=1.0000000 + dnfactorp3 pnfactor=0 + dpnfactorp3
+ wnfactor=0 + dwnfactorp3 lnfactor=0 + dlnfactorp3
+ cit=4.9963790e-04 lcit=2.6027104e-12 cdsc=0.00
+ cdscb=0.00 cdscd=0.00
+ eta0= - 4.2714270e-05 + deta0p3 peta0=0 + dpeta0p3
+ weta0=0 + dweta0p3 leta0=5.8512850e-11 + dleta0p3
+ etab=4.2714270e-05 letab=-5.8512850e-11 dsub=0.00
+ pclm=0.5865320 lpclm=4.0258040e-08 pdiblc1=1.0000000e-06
+ pdiblc2=-5.6985720e-04 lpdiblc2=6.4364150e-10 pdiblcb=1.0000000e-02
+ drout=0.00 pscbe1=2.7071427e08 lpscbe1=32.5071400
+ pscbe2=5.0000000e-07 pvag=0.00 delta=1.0000000e-02
+ alpha0=0.00 alpha1=0.143217238 beta0=16.10832
+ kt1=-0.2962146 lkt1=-2.2099222e-09 kt2=-2.4729839e-02
+ lkt2=-1.5262811e-09 at=-5.0000000e04 ute=-0.7447437
+ lute=5.5271930e-08 ua1=2.0310000e-09 ub1=-2.7745749e-18
+ lub1=2.8973695e-25 uc1=2.7087265e-11 luc1=1.5749189e-19
+ kt1l=0.00 prt=0 cj=cjp3
+ pb=0.8049122 mj=0.3954951 cjsw=cjswp3
+ pbsw=0.8049122 mjsw=0.2573111 cjswg=cjswgp3
+ pbswg=0.8049122 mjswg=0.2573111 cgdo=cgop3
+ cgso=cgop3 tcj=0.0009940197 tcjsw=0.0006908749
+ tcjswg=0.0006908749 tpb=0.001625007 tpbsw=0.001625007
+ tpbswg=0.001625007 js=1.900e-07 jsw=1.00e-12
+ n=1 xti=3 capmod=3
+ nqsmod=0 xpart=1 cf=0
+ tlev=1 tlevc=1
+ llc=-0.0165 noimod=2
+ noia=2.0e19 noib=8.0e03 noic=5.4e-12
+ em=3.0e07 ef=1.094
+ minr=1e-60 imax=0.01 imelt=0.01

 4: type=p
+ lmin=3.0e-007 lmax=5.000e-07 - dxlp3 wmin=1.0000e-05 - dxwp3
+ wmax=900.001e-6 tnom=25.0 version=3.24
+ tox=toxp3 toxm=6.77e-09 xj=1.7000001e-07
+ nch=4.9500000e17 lln=-1 lwn=1.0000000
+ wln=1.0000000 wwn=1.0000000 lint=3.5000000e-08
+ ll=0.00 lw=0.00 lwl=0.00
+ wint=2.0000000e-08 wl=0.00 ww=0.00
+ wwl=0.00 mobmod=1 binunit=2
+ xl= - 0.02e-6 + dxlp3 xw=0.0 + dxwp3 dwg=0.00
+ dwb=0.00 ldif=9.00e-08
+ hdif=hdifp3 rsh=rshp3 rd=0
+ rs=0 vth0= - 0.7654887 + dvthp3
+ pvth0=0 + dpvthp3 wvth0=0 + dwvthp3
+ lvth0=2.4360313e-08 + dlvthp3 k1=0.7697587
+ lk1=4.7337540e-08 k2=0.1288249 + dk2p3
+ lk2= - 2.8482381e-08 + dlk2p3 k3=0.00
+ dvt0=0.00 dvt1=0.00 dvt2=0.00
+ dvt0w=0.00 dvt1w=0.00 dvt2w=0.00
+ nlx=0.00 w0=0.00 k3b=0.00
+ vsat=1.2050377e05 + dvsatp3 wvsat=0 + dwvsatp3
+ lvsat=-4.3065240e-03 ua=1.2215998e-09 lua=-1.7604479e-16
+ ub=1.0977573e-19 lub=2.5871919e-25 uc=-8.9515780e-11
+ luc=2.6582101e-17 rdsw=9.0000000e02 prwb=0.00
+ prwg=0.00 wr=1.0000000 u0=1.0026056e-02 + du0p3
+ pu0=0 + dpu0p3 wu0=0 + dwu0p3
+ lu0= - 6.1558890e-11 + dlu0p3 a0=1.1557579
+ la0=-8.6956350e-08 keta=-9.8874240e-03 lketa=1.1849141e-09
+ a1=0.00 a2=0.9900000 ags=2.0000000e-02
+ b0=0.00 b1=0.00
+ voff= - 0.1251169 + dvoffp3 pvoff=0 + dpvoffp3
+ wvoff=0 + dwvoffp3 lvoff=8.6701580e-09 + dlvoffp3
+ nfactor=1.0000000 + dnfactorp3 pnfactor=0 + dpnfactorp3
+ wnfactor=0 + dwnfactorp3 lnfactor=0 + dlnfactorp3
+ cit=5.4583350e-04 lcit=-1.6337489e-11 cdsc=0.00
+ cdscb=0.00 cdscd=0.00
+ eta0= - 3.2014790e-04 + deta0p3 peta0=0 + dpeta0p3
+ weta0=0 + dweta0p3 leta0=1.7226064e-10 + dleta0p3
+ etab=8.4486390e-04 letab=-3.8739420e-10 dsub=0.00
+ pclm=0.6685342 lpclm=6.6371640e-09 pdiblc1=1.0000000e-06
+ pdiblc2=-3.1977270e-03 lpdiblc2=1.7210681e-09 pdiblcb=1.0000000e-02
+ drout=0.00 pscbe1=3.2899260e08 lpscbe1=8.6130450
+ pscbe2=5.0000000e-07 pvag=0.00 delta=1.0000000e-02
+ alpha0=0.00 alpha1=0.143217238 beta0=16.10832
+ kt1=-0.3347960 lkt1=1.3608444e-08 kt2=-3.0659514e-02
+ lkt2=9.0488570e-10 at=-5.0000000e04 ute=-0.1691541
+ lute=-1.8071982e-07 ua1=3.4398240e-09 lua1=-5.7761800e-16
+ ub1=-2.4997837e-18 lub1=1.7707251e-25 uc1=5.3556920e-11
+ luc1=-1.0695066e-17 kt1l=0.00 prt=0
+ cj=cjp3 pb=0.8049122 mj=0.3954951
+ cjsw=cjswp3 pbsw=0.8049122 mjsw=0.2573111
+ cjswg=cjswgp3 pbswg=0.8049122 mjswg=0.2573111
+ cgdo=cgop3 cgso=cgop3 tcj=0.0009940197
+ tcjsw=0.0006908749 tcjswg=0.0006908749 tpb=0.001625007
+ tpbsw=0.001625007 tpbswg=0.001625007 js=1.900e-07
+ jsw=1.00e-12 n=1 xti=3
+ capmod=3 nqsmod=0 xpart=1
+ cf=0 tlev=1 tlevc=1
+ llc=-0.0165
+ noimod=2 noia=2.0e19 noib=8.0e03
+ noic=5.4e-12 em=3.0e07 ef=1.094
+ minr=1e-60 imax=0.01 imelt=0.01

 5: type=p
+ lmin=1.000e-05 - dxlp3 lmax=20.001e-006 wmin=1.2000e-06 - dxwp3
+ wmax=1.0000e-05 - dxwp3 tnom=25.0 version=3.24
+ tox=toxp3 toxm=6.77e-09 xj=1.7000001e-07
+ nch=4.9500000e17 lln=-1 lwn=1.0000000
+ wln=1.0000000 wwn=1.0000000 lint=3.5000000e-08
+ ll=0.00 lw=0.00 lwl=0.00
+ wint=2.0000000e-08 wl=0.00 ww=0.00
+ wwl=0.00 mobmod=1 binunit=2
+ xl= - 0.02e-6 + dxlp3 xw=0.0 + dxwp3 dwg=0.00
+ dwb=0.00 ldif=9.00e-08
+ hdif=hdifp3 rsh=rshp3 rd=0
+ rs=0 vth0= - 0.6984460 + dvthp3
+ pvth0=0 + dpvthp3 lvth0=0 + dlvthp3
+ wvth0=6.9768680e-09 + dwvthp3 k1=0.8503587
+ wk1=1.0315638e-08 k2=7.3487820e-02 + dk2p3
+ lk2=0 + dlk2p3 wk2=-2.5573503e-09 k3=0.00
+ dvt0=0.00 dvt1=0.00 dvt2=0.00
+ dvt0w=0.00 dvt1w=0.00 dvt2w=0.00
+ nlx=0.00 w0=0.00 k3b=0.00
+ vsat=1.5000002e05 + dvsatp3 wvsat=0 + dwvsatp3
+ ua=1.6894739e-09 wua=-1.0194988e-16 ub=3.0589336e-19
+ wub=-2.9683633e-25 uc=-9.9785820e-11 wuc=-6.4985050e-17
+ rdsw=9.0000000e02 prwb=0.00 prwg=0.00
+ wr=1.0000000 u0=1.3156584e-02 + du0p3
+ pu0=0 + dpu0p3 lu0=0 + dlu0p3
+ wu0= - 7.7172380e-10 + dwu0p3 a0=0.9693438
+ wa0=3.2530650e-08 keta=1.9776296e-02 wketa=-1.9673381e-09
+ a1=0.00 a2=0.9900000 ags=2.0000000e-02
+ b0=0.00 b1=0.00
+ voff= - 0.1118388 + dvoffp3 pvoff=0 + dpvoffp3
+ lvoff=0 + dlvoffp3 wvoff= - 8.5173270e-10 + dwvoffp3
+ nfactor=1.0000000 + dnfactorp3 pnfactor=0 + dpnfactorp3
+ wnfactor=0 + dwnfactorp3 lnfactor=0 + dlnfactorp3
+ cit=4.5291100e-04 wcit=8.0838530e-12 cdsc=0.00
+ cdscb=0.00 cdscd=0.00
+ eta0=1.0000000e-05 + deta0p3 peta0=0 + dpeta0p3
+ weta0=0 + dweta0p3 leta0=0 + dleta0p3 etab=-1.0000000e-05
+ dsub=0.00 pclm=0.5000001 pdiblc1=1.0000000e-06
+ pdiblc2=1.0000000e-05 pdiblcb=1.0000000e-02 drout=0.00
+ pscbe1=2.0000003e08 pscbe2=5.0000000e-07 pvag=0.00
+ delta=1.0000000e-02 alpha0=0.00 alpha1=0.143217238
+ beta0=16.10832 kt1=-0.2916738 wkt1=3.7208530e-09
+ kt2=-2.5821852e-02 wkt2=-6.8693400e-10 at=-5.0000000e04
+ ute=-0.8086289 wute=1.2628378e-07 ua1=2.0310000e-09
+ ub1=-2.6415932e-18 wub1=1.8323023e-25 uc1=4.3590560e-12
+ wuc1=5.0558750e-17 kt1l=0.00 prt=0
+ cj=cjp3 pb=0.8049122 mj=0.3954951
+ cjsw=cjswp3 pbsw=0.8049122 mjsw=0.2573111
+ cjswg=cjswgp3 pbswg=0.8049122 mjswg=0.2573111
+ cgdo=cgop3 cgso=cgop3 tcj=0.0009940197
+ tcjsw=0.0006908749 tcjswg=0.0006908749 tpb=0.001625007
+ tpbsw=0.001625007 tpbswg=0.001625007 js=1.900e-07
+ jsw=1.00e-12 n=1 xti=3
+ capmod=3 nqsmod=0 xpart=1
+ cf=0 tlev=1 tlevc=1
+ llc=-0.0165
+ noimod=2 noia=2.0e19 noib=8.0e03
+ noic=5.4e-12 em=3.0e07 ef=1.094
+ minr=1e-60 imax=0.01 imelt=0.01

 6: type=p
+ lmin=1.200e-06 - dxlp3 lmax=1.000e-05 - dxlp3 wmin=1.2000e-06 - dxwp3
+ wmax=1.0000e-05 - dxwp3 tnom=25.0 version=3.24
+ tox=toxp3 toxm=6.77e-09 xj=1.7000001e-07
+ nch=4.9500000e17 lln=-1 lwn=1.0000000
+ wln=1.0000000 wwn=1.0000000 lint=3.5000000e-08
+ ll=0.00 lw=0.00 lwl=0.00
+ wint=2.0000000e-08 wl=0.00 ww=0.00
+ wwl=0.00 mobmod=1 binunit=2
+ xl= - 0.02e-6 + dxlp3 xw=0.0 + dxwp3 dwg=0.00
+ dwb=0.00 ldif=9.00e-08
+ hdif=hdifp3 rsh=rshp3 rd=0
+ rs=0 vth0= - 0.6973685 + dvthp3
+ lvth0= - 1.0678359e-08 + dlvthp3
+ wvth0=7.1662300e-09 + dwvthp3
+ pvth0= - 1.8765835e-15 + dpvthp3 k1=0.8484218
+ lk1=1.9194855e-08 wk1=1.1689406e-08 pk1=-1.3614034e-14
+ k2=7.4132180e-02 + dk2p3
+ lk2= - 6.3856390e-09 + dlk2p3 wk2=-2.8581482e-09
+ pk2=2.9809131e-15 k3=0.00 dvt0=0.00
+ dvt1=0.00 dvt2=0.00 dvt0w=0.00
+ dvt1w=0.00 dvt2w=0.00 nlx=0.00
+ w0=0.00 k3b=0.00
+ vsat=1.5378411e05 + dvsatp3 wvsat=0 + dwvsatp3
+ lvsat=-3.7500340e-02 ua=1.7025260e-09 lua=-1.2934621e-16
+ wua=-1.2229349e-16 pua=2.0160552e-22 ub=2.9719795e-19
+ lub=8.6171280e-26 wub=-2.8674966e-25 pub=-9.9958690e-32
+ uc=-1.0189776e-10 luc=2.0929388e-17 wuc=-6.3469690e-17
+ puc=-1.5017275e-23 rdsw=9.0000000e02 prwb=0.00
+ prwg=0.00 wr=1.0000000 u0=1.3313532e-02 + du0p3
+ lu0= - 1.5553542e-09 + dlu0p3
+ wu0= - 8.0194040e-10 + dwu0p3
+ pu0=2.9944828e-16 + dpu0p3 a0=0.9772012
+ la0=-7.7866310e-08 wa0=3.5253190e-08 pa0=-2.6980386e-14
+ keta=2.0953476e-02 lketa=-1.1665868e-08 wketa=-2.0108260e-09
+ pketa=4.3096390e-16 a1=0.00 a2=0.9900000
+ ags=2.0000000e-02 b0=0.00 b1=0.00
+ voff= - 0.1118283 + dvoffp3
+ lvoff= - 1.0463946e-10 + dlvoffp3
+ wvoff= - 7.1421570e-10 + dwvoffp3
+ pvoff= - 1.3627949e-15 + dpvoffp3
+ nfactor=1.0000000 + dnfactorp3 pnfactor=0 + dpnfactorp3
+ wnfactor=0 + dwnfactorp3 lnfactor=0 + dlnfactorp3
+ cit=4.4620200e-04 lcit=6.6485910e-11 wcit=1.4275149e-11
+ pcit=-6.1355780e-17 cdsc=0.00 cdscb=0.00
+ cdscd=0.00 eta0=1.0000000e-05 + deta0p3
+ peta0=0 + dpeta0p3 weta0=0 + dweta0p3 leta0=0 + dleta0p3
+ etab=-1.0000000e-05 dsub=0.00 pclm=0.4849888
+ lpclm=1.4876132e-07 wpclm=-4.7646440e-09 ppclm=4.7216950e-14
+ pdiblc1=1.0000000e-06 pdiblc2=1.0000000e-05 pdiblcb=1.0000000e-02
+ drout=0.00 pscbe1=1.8738640e08 lpscbe1=1.2500110e02
+ pscbe2=5.0000000e-07 pvag=0.00 delta=1.0000000e-02
+ alpha0=0.00 alpha1=0.143217238 beta0=16.10832
+ kt1=-0.2907380 lkt1=-9.2738370e-09 wkt1=3.0755010e-09
+ pkt1=6.3954390e-15 kt2=-2.5782341e-02 lkt2=-3.9155450e-10
+ wkt2=-8.1155670e-10 pkt2=1.2350112e-15 at=-5.0000000e04
+ ute=-0.8213636 lute=1.2620113e-07 wute=1.2623275e-07
+ pute=5.0573060e-16 ua1=2.0310000e-09 ub1=-2.6567511e-18
+ lub1=1.5021592e-25 wub1=1.9645394e-25 pub1=-1.3104698e-31
+ uc1=2.3076966e-12 luc1=2.0329014e-17 wuc1=4.8635520e-17
+ puc1=1.9059230e-23 kt1l=0.00 prt=0
+ cj=cjp3 pb=0.8049122 mj=0.3954951
+ cjsw=cjswp3 pbsw=0.8049122 mjsw=0.2573111
+ cjswg=cjswgp3 pbswg=0.8049122 mjswg=0.2573111
+ cgdo=cgop3 cgso=cgop3 tcj=0.0009940197
+ tcjsw=0.0006908749 tcjswg=0.0006908749 tpb=0.001625007
+ tpbsw=0.001625007 tpbswg=0.001625007 js=1.900e-07
+ jsw=1.00e-12 n=1 xti=3
+ capmod=3 nqsmod=0 xpart=1
+ cf=0 tlev=1 tlevc=1
+ llc=-0.0165
+ noimod=2 noia=2.0e19 noib=8.0e03
+ noic=5.4e-12 em=3.0e07 ef=1.094
+ minr=1e-60 imax=0.01 imelt=0.01

 7: type=p
+ lmin=5.000e-07 - dxlp3 lmax=1.200e-06 - dxlp3 wmin=1.2000e-06 - dxwp3
+ wmax=1.0000e-05 - dxwp3 tnom=25.0 version=3.24
+ tox=toxp3 toxm=6.77e-09 xj=1.7000001e-07
+ nch=4.9500000e17 lln=-1 lwn=1.0000000
+ wln=1.0000000 wwn=1.0000000 lint=3.5000000e-08
+ ll=0.00 lw=0.00 lwl=0.00
+ wint=2.0000000e-08 wl=0.00 ww=0.00
+ wwl=0.00 mobmod=1 binunit=2
+ xl= - 0.02e-6 + dxlp3 xw=0.0 + dxwp3 dwg=0.00
+ dwb=0.00 ldif=9.00e-08
+ hdif=hdifp3 rsh=rshp3 rd=0
+ rs=0 vth0= - 0.7063123 + dvthp3
+ lvth0= - 7.5076820e-10 + dlvthp3
+ wvth0= - 3.3938940e-09 + dwvthp3
+ pvth0=9.8451550e-15 + dpvthp3 k1=0.8532185
+ lk1=1.3870451e-08 wk1=9.7791290e-09 pk1=-1.1493628e-14
+ k2=7.3774080e-02 + dk2p3
+ lk2= - 5.9881520e-09 + dlk2p3 wk2=-1.3637474e-09
+ pk2=1.3221279e-15 k3=0.00 dvt0=0.00
+ dvt1=0.00 dvt2=0.00 dvt0w=0.00
+ dvt1w=0.00 dvt2w=0.00 nlx=0.00
+ w0=0.00 k3b=0.00
+ vsat=1.2585714e05 + dvsatp3 wvsat=0 + dwvsatp3
+ lvsat=-6.5014080e-03 ua=2.0674848e-09 lua=-5.3445060e-16
+ wua=-7.0865140e-17 pua=1.4452005e-22 ub=1.2599716e-19
+ lub=2.7620414e-25 wub=-2.5408411e-25 pub=-1.3621745e-31
+ uc=-1.2225446e-10 luc=4.3525310e-17 wuc=-7.2008350e-17
+ puc=-5.5393540e-24 rdsw=9.0000000e02 prwb=0.00
+ prwg=0.00 wr=1.0000000 u0=1.3079622e-02 + du0p3
+ lu0= - 1.2957146e-09 + dlu0p3
+ wu0= - 5.9050560e-10 + dwu0p3
+ pu0=6.4755580e-17 + dpu0p3 a0=0.8879921
+ la0=2.1155756e-08 wa0=-6.4301090e-09 pa0=1.9288072e-14
+ keta=2.0470830e-02 lketa=-1.1130130e-08 wketa=-6.9703380e-10
+ pketa=-1.0273464e-15 a1=0.00 a2=0.9900000
+ ags=2.0000000e-02 b0=0.00 b1=0.00
+ voff= - 0.1170540 + dvoffp3
+ lvoff=5.6959450e-09 + dlvoffp3
+ wvoff=1.6383606e-09 + dwvoffp3
+ pvoff= - 3.9741550e-15 + dpvoffp3
+ nfactor=1.0000000 + dnfactorp3 pnfactor=0 + dpnfactorp3
+ wnfactor=0 + dwnfactorp3 lnfactor=0 + dlnfactorp3
+ cit=5.0421500e-04 lcit=2.0914730e-12 wcit=-4.5587650e-11
+ pcit=5.0919230e-18 cdsc=0.00 cdscb=0.00
+ cdscd=0.00 eta0= - 4.2714280e-05 + deta0p3
+ peta0=0 + dpeta0p3 weta0=0 + dweta0p3
+ leta0=5.8512850e-11 + dleta0p3 etab=4.2714280e-05
+ letab=-5.8512850e-11 dsub=0.00 pclm=0.5832995
+ lpclm=3.9636520e-08 wpclm=3.2196260e-08 ppclm=6.1903360e-15
+ pdiblc1=1.0000000e-06 pdiblc2=-5.6985730e-04 lpdiblc2=6.4364150e-10
+ pdiblcb=1.0000000e-02 drout=0.00 pscbe1=2.7071427e08
+ lpscbe1=32.5071400 pscbe2=5.0000000e-07 pvag=0.00
+ delta=1.0000000e-02 alpha0=0.00 alpha1=0.143217238
+ beta0=16.10832 kt1=-0.2971400 lkt1=-2.1676729e-09
+ wkt1=9.2162620e-09 pkt1=-4.2080570e-16 kt2=-2.4722382e-02
+ lkt2=-1.5681096e-09 wkt2=-7.4258340e-11 pkt2=4.1660990e-16
+ at=-5.0000000e04 ute=-0.7553561 lute=5.2932850e-08
+ wute=1.0569979e-07 pute=2.3297301e-14 ua1=2.0310000e-09
+ ub1=-2.7846704e-18 lub1=2.9220633e-25 wub1=1.0055110e-25
+ pub1=-2.4594843e-32 uc1=1.9397399e-11 luc1=1.3594401e-18
+ wuc1=7.6591040e-17 puc1=-1.1971389e-23 kt1l=0.00
+ prt=0 cj=cjp3 pb=0.8049122
+ mj=0.3954951 cjsw=cjswp3 pbsw=0.8049122
+ mjsw=0.2573111 cjswg=cjswgp3 pbswg=0.8049122
+ mjswg=0.2573111 cgdo=cgop3 cgso=cgop3
+ tcj=0.0009940197 tcjsw=0.0006908749 tcjswg=0.0006908749
+ tpb=0.001625007 tpbsw=0.001625007 tpbswg=0.001625007
+ js=1.900e-07 jsw=1.00e-12 n=1
+ xti=3 capmod=3 nqsmod=0
+ xpart=1 cf=0 tlev=1
+ tlevc=1
+ llc=-0.0165 noimod=2 noia=2.0e19
+ noib=8.0e03 noic=5.4e-12 em=3.0e07
+ ef=1.094
+ minr=1e-60 imax=0.01 imelt=0.01

 8: type=p
+ lmin=3.0e-007 lmax=5.000e-07 - dxlp3 wmin=1.2000e-06 - dxwp3
+ wmax=1.0000e-05 - dxwp3 tnom=25.0 version=3.24
+ tox=toxp3 toxm=6.77e-09 xj=1.7000001e-07
+ nch=4.9500000e17 lln=-1 lwn=1.0000000
+ wln=1.0000000 wwn=1.0000000 lint=3.5000000e-08
+ ll=0.00 lw=0.00 lwl=0.00
+ wint=2.0000000e-08 wl=0.00 ww=0.00
+ wwl=0.00 mobmod=1 binunit=2
+ xl= - 0.02e-6 + dxlp3 xw=0.0 + dxwp3 dwg=0.00
+ dwb=0.00 ldif=9.00e-08
+ hdif=hdifp3 rsh=rshp3 rd=0
+ rs=0 vth0= - 0.7727100 + dvthp3
+ lvth0=2.6472314e-08 + dlvthp3
+ wvth0=7.1924870e-08 + dwvthp3
+ pvth0= - 2.1035541e-14 + dpvthp3 k1=0.7699419
+ lk1=4.8013860e-08 wk1=-1.8243896e-09 pk1=-6.7361810e-15
+ k2=0.1315423 + dk2p3 lk2= - 2.9673100e-08 + dlk2p3
+ wk2=-2.7064845e-08 pk2=1.1859575e-14 k3=0.00
+ dvt0=0.00 dvt1=0.00 dvt2=0.00
+ dvt0w=0.00 dvt1w=0.00 dvt2w=0.00
+ nlx=0.00 w0=0.00 k3b=0.00
+ vsat=1.1960348e05 + dvsatp3 lvsat=-3.9374090e-03
+ wvsat=8.9667880e-03 + dwvsatp3 pvsat=-3.6763830e-09
+ ua=1.1489469e-09 lua=-1.5785002e-16 wua=7.2362290e-16
+ pua=-1.8122008e-22 ub=2.4514955e-19 lub=2.2735166e-25
+ wub=-1.3483237e-24 pub=3.1242082e-31 uc=-7.1838280e-11
+ luc=2.2854683e-17 wuc=-1.7606797e-16 puc=3.7125090e-23
+ rdsw=9.0000000e02 prwb=0.00 prwg=0.00
+ wr=1.0000000 u0=1.0090719e-02 + du0p3
+ lu0= - 7.0264360e-11 + dlu0p3
+ wu0= - 6.4404460e-10 + dwu0p3
+ pu0=8.6706510e-17 + dpu0p3 a0=1.1409379
+ la0=-8.2552040e-08 wa0=1.4760643e-07 pa0=-4.3866910e-14
+ keta=-1.1318877e-02 lketa=1.9036506e-09 wketa=1.4257295e-08
+ pketa=-7.1586210e-15 a1=0.00 a2=0.9900000
+ ags=2.0000000e-02 b0=0.00 b1=0.00
+ voff= - 0.1250223 + dvoffp3
+ lvoff=8.9629090e-09 + dlvoffp3
+ wvoff= - 9.4300550e-10 + dwvoffp3
+ pvoff= - 2.9157947e-15 + dpvoffp3
+ nfactor=1.0000000 + dnfactorp3 pnfactor=0 + dpnfactorp3
+ wnfactor=0 + dwnfactorp3 lnfactor=0 + dlnfactorp3
+ cit=5.6188450e-04 lcit=-2.1553027e-11 wcit=-1.5986783e-10
+ pcit=5.1946790e-17 cdsc=0.00 cdscb=0.00
+ cdscd=0.00 eta0= - 2.8413706e-04 + deta0p3
+ leta0=1.5749620e-10 + dleta0p3
+ weta0= - 3.5866790e-10 + dweta0p3
+ peta0=1.4705383e-16 + dpeta0p3 etab=8.7586620e-04
+ letab=-4.0010520e-10 wetab=-3.0878400e-10 petab=1.2660141e-16
+ dsub=0.00 pclm=0.6645077 lpclm=6.3411240e-09
+ wpclm=4.0103030e-08 ppclm=2.9485615e-15 pdiblc1=1.0000000e-06
+ pdiblc2=-3.7510620e-03 lpdiblc2=1.9479358e-09 wpdiblc2=5.5112340e-09
+ ppdiblc2=-2.2596061e-15 pdiblcb=1.0000000e-02 drout=0.00
+ pscbe1=3.3079310e08 lpscbe1=7.8748250 wpscbe1=-17.9333440
+ ppscbe1=7.3526710e-06 pscbe2=5.0000000e-07 pvag=0.00
+ delta=1.0000000e-02 alpha0=0.00 alpha1=0.143217238
+ beta0=16.10832 kt1=-0.3349694 lkt1=1.3342398e-08
+ wkt1=1.7269201e-09 pkt1=2.6498244e-15 kt2=-3.0737475e-02
+ lkt2=8.9807820e-10 wkt2=7.7649210e-10 pkt2=6.7802250e-17
+ at=-5.0000000e04 ute=-0.1318164 lute=-2.0271844e-07
+ wute=-3.7188310e-07 pute=2.1910628e-13 ua1=3.6255330e-09
+ lua1=-6.5375860e-16 wua1=-1.8496589e-15 pua1=7.5836000e-22
+ ub1=-2.5613780e-18 lub1=2.0065643e-25 wub1=6.1348050e-25
+ pub1=-2.3489589e-31 uc1=4.8751200e-11 luc1=-1.0675619e-17
+ wuc1=4.7864960e-17 puc1=-1.9370043e-25 kt1l=0.00
+ prt=0 cj=cjp3 pb=0.8049122
+ mj=0.3954951 cjsw=cjswp3 pbsw=0.8049122
+ mjsw=0.2573111 cjswg=cjswgp3 pbswg=0.8049122
+ mjswg=0.2573111 cgdo=cgop3 cgso=cgop3
+ tcj=0.0009940197 tcjsw=0.0006908749 tcjswg=0.0006908749
+ tpb=0.001625007 tpbsw=0.001625007 tpbswg=0.001625007
+ js=1.900e-07 jsw=1.00e-12 n=1
+ xti=3 capmod=3 nqsmod=0
+ xpart=1 cf=0 tlev=1
+ tlevc=1
+ llc=-0.0165 noimod=2 noia=2.0e19
+ noib=8.0e03 noic=5.4e-12 em=3.0e07
+ ef=1.094
+ minr=1e-60 imax=0.01 imelt=0.01

 9: type=p
+ lmin=1.000e-05 - dxlp3 lmax=20.001e-006 wmin=5.0000e-07 - dxwp3
+ wmax=1.2000e-06 - dxwp3 tnom=25.0 version=3.24
+ tox=toxp3 toxm=6.77e-09 xj=1.7000001e-07
+ nch=4.9500000e17 lln=-1 lwn=1.0000000
+ wln=1.0000000 wwn=1.0000000 lint=3.5000000e-08
+ ll=0.00 lw=0.00 lwl=0.00
+ wint=2.0000000e-08 wl=0.00 ww=0.00
+ wwl=0.00 mobmod=1 binunit=2
+ xl= - 0.02e-6 + dxlp3 xw=0.0 + dxwp3 dwg=0.00
+ dwb=0.00 ldif=9.00e-08
+ hdif=hdifp3 rsh=rshp3 rd=0
+ rs=0 vth0= - 0.6992865 + dvthp3
+ pvth0=0 + dpvthp3 lvth0=0 + dlvthp3
+ wvth0=7.9518050e-09 + dwvthp3 k1=0.8536492
+ wk1=6.4986320e-09 k2=7.3503040e-02 + dk2p3
+ lk2=0 + dlk2p3 wk2=-2.5750040e-09 k3=0.00
+ dvt0=0.00 dvt1=0.00 dvt2=0.00
+ dvt0w=0.00 dvt1w=0.00 dvt2w=0.00
+ nlx=0.00 w0=0.00 k3b=0.00
+ vsat=1.5000002e05 + dvsatp3 wvsat=0 + dwvsatp3
+ ua=2.3221998e-09 wua=-8.3591190e-16 ub=5.0000000e-20
+ uc=-1.3989673e-10 wuc=-1.8456393e-17 rdsw=9.0000000e02
+ prwb=0.00 prwg=0.00 wr=1.0000000
+ u0=1.4610297e-02 + du0p3 pu0=0 + dpu0p3
+ lu0=0 + dlu0p3 wu0= - 2.4580307e-09 + dwu0p3
+ a0=0.9420360 wa0=6.4207830e-08 keta=1.8767053e-02
+ wketa=-7.9661680e-10 a1=0.00 a2=0.9900000
+ ags=2.0000001e-02 b0=0.00 b1=0.00
+ voff= - 0.1126554 + dvoffp3 pvoff=0 + dpvoffp3
+ lvoff=0 + dlvoffp3 wvoff=9.5426480e-11 + dwvoffp3
+ nfactor=1.0000000 + dnfactorp3 pnfactor=0 + dpnfactorp3
+ wnfactor=0 + dwnfactorp3 lnfactor=0 + dlnfactorp3
+ cit=4.8056380e-04 wcit=-2.3993458e-11 cdsc=0.00
+ cdscb=0.00 cdscd=0.00
+ eta0=1.0000000e-05 + deta0p3 peta0=0 + dpeta0p3
+ weta0=0 + dweta0p3 leta0=0 + dleta0p3 etab=-1.0000000e-05
+ dsub=0.00 pclm=0.5000000 pdiblc1=1.0000000e-06
+ pdiblc2=1.0000000e-05 pdiblcb=1.0000000e-02 drout=0.00
+ pscbe1=2.0000003e08 pscbe2=5.0000000e-07 pvag=0.00
+ delta=1.0000000e-02 alpha0=0.00 alpha1=0.143217238
+ beta0=16.10832 kt1=-0.2917677 wkt1=3.8297360e-09
+ kt2=-2.7259111e-02 wkt2=9.8028660e-10 at=-5.0000000e04
+ ute=-0.7662017 wute=7.7068240e-08 ua1=2.0309998e-09
+ ub1=-2.5738963e-18 wub1=1.0470186e-25 uc1=4.6204500e-11
+ wuc1=2.0180378e-18 kt1l=0.00 prt=0
+ cj=cjp3 pb=0.8049122 mj=0.3954951
+ cjsw=cjswp3 pbsw=0.8049122 mjsw=0.2573111
+ cjswg=cjswgp3 pbswg=0.8049122 mjswg=0.2573111
+ cgdo=cgop3 cgso=cgop3 tcj=0.0009940197
+ tcjsw=0.0006908749 tcjswg=0.0006908749 tpb=0.001625007
+ tpbsw=0.001625007 tpbswg=0.001625007 js=1.900e-07
+ jsw=1.00e-12 n=1 xti=3
+ capmod=3 nqsmod=0 xpart=1
+ cf=0 tlev=1 tlevc=1
+ llc=-0.0165
+ noimod=2 noia=2.0e19 noib=8.0e03
+ noic=5.4e-12 em=3.0e07 ef=1.094
+ minr=1e-60 imax=0.01 imelt=0.01

 10: type=p
+ lmin=1.200e-06 - dxlp3 lmax=1.000e-05 - dxlp3 wmin=5.0000e-07 - dxwp3
+ wmax=1.2000e-06 - dxwp3 tnom=25.0 version=3.24
+ tox=toxp3 toxm=6.77e-09 xj=1.7000001e-07
+ nch=4.9500000e17 lln=-1 lwn=1.0000000
+ wln=1.0000000 wwn=1.0000000 lint=3.5000000e-08
+ ll=0.00 lw=0.00 lwl=0.00
+ wint=2.0000000e-08 wl=0.00 ww=0.00
+ wwl=0.00 mobmod=1 binunit=2
+ xl= - 0.02e-6 + dxlp3 xw=0.0 + dxwp3 dwg=0.00
+ dwb=0.00 ldif=9.00e-08
+ hdif=hdifp3 rsh=rshp3 rd=0
+ rs=0 vth0= - 0.6977277 + dvthp3
+ lvth0= - 1.5447748e-08 + dlvthp3
+ wvth0=7.5828930e-09 + dwvthp3
+ pvth0=3.6559090e-15 + dpvthp3 k1=0.8533953
+ lk1=2.5154285e-09 wk1=5.9200140e-09 pk1=5.7341030e-15
+ k2=7.3639660e-02 + dk2p3
+ lk2= - 1.3539118e-09 + dlk2p3 wk2=-2.2868212e-09
+ pk2=-2.8558914e-15 k3=0.00 dvt0=0.00
+ dvt1=0.00 dvt2=0.00 dvt0w=0.00
+ dvt1w=0.00 dvt2w=0.00 nlx=0.00
+ w0=0.00 k3b=0.00
+ vsat=1.5378411e05 + dvsatp3 wvsat=0 + dwvsatp3
+ lvsat=-3.7500340e-02 ua=2.3145617e-09 lua=7.5691840e-17
+ wua=-8.3225500e-16 pua=-3.6238470e-23 ub=5.0000000e-20
+ uc=-1.4156483e-10 luc=1.6530885e-17 wuc=-1.7455885e-17
+ puc=-9.9150150e-24 rdsw=9.0000000e02 prwb=0.00
+ prwg=0.00 wr=1.0000000 u0=1.4772911e-02 + du0p3
+ lu0= - 1.6115109e-09 + dlu0p3
+ wu0= - 2.4948206e-09 + dwu0p3
+ pu0=3.6459010e-16 + dpu0p3 a0=0.9551688
+ la0=-1.3014645e-07 wa0=6.0810790e-08 pa0=3.3664580e-14
+ keta=1.9918669e-02 lketa=-1.1412505e-08 wketa=-8.1044770e-10
+ pketa=1.3706199e-16 a1=0.00 a2=0.9900000
+ ags=1.9607194e-02 lags=3.8927150e-09 wags=4.5565450e-10
+ pags=-4.5155490e-15 b0=0.00 b1=0.00
+ voff= - 0.1124224 + dvoffp3
+ lvoff= - 2.3088516e-09 + dlvoffp3
+ wvoff= - 2.5067145e-11 + dwvoffp3
+ pvoff=1.1940914e-15 + dpvoffp3
+ nfactor=1.0000000 + dnfactorp3 pnfactor=0 + dpnfactorp3
+ wnfactor=0 + dwnfactorp3 lnfactor=0 + dlnfactorp3
+ cit=4.8383600e-04 lcit=-3.2427540e-11 wcit=-2.9380325e-11
+ pcit=5.3383830e-17 cdsc=0.00 cdscb=0.00
+ cdscd=0.00 eta0=1.0000000e-05 + deta0p3
+ peta0=0 + dpeta0p3 weta0=0 + dweta0p3 leta0=0 + dleta0p3
+ etab=-1.0000000e-05 dsub=0.00 pclm=0.4848956
+ lpclm=1.4968438e-07 wpclm=-4.6565580e-09 ppclm=4.6146210e-14
+ pdiblc1=1.0000000e-06 pdiblc2=1.0000000e-05 pdiblcb=1.0000000e-02
+ drout=0.00 pscbe1=1.8738640e08 lpscbe1=1.2500110e02
+ pscbe2=5.0000000e-07 pvag=0.00 delta=1.0000000e-02
+ alpha0=0.00 alpha1=0.143217238 beta0=16.10832
+ kt1=-0.2911539 lkt1=-6.0821800e-09 wkt1=3.5579780e-09
+ pkt1=2.6931163e-15 kt2=-2.7373781e-02 lkt2=1.1363845e-09
+ wkt2=1.0345145e-09 pkt2=-5.3739830e-16 at=-5.0000000e04
+ ute=-0.7822405 lute=1.5894491e-07 wute=8.0849990e-08
+ pute=-3.7477070e-14 ua1=2.0253581e-09 lua1=5.5907670e-17
+ wua1=6.5445300e-18 pua1=-6.4852900e-23 ub1=-2.5749808e-18
+ lub1=1.0747389e-26 wub1=1.0160029e-25 pub1=3.0736538e-32
+ uc1=4.3742250e-11 luc1=2.4400898e-17 wuc1=5.7143320e-19
+ puc1=1.4335845e-23 kt1l=0.00 prt=0
+ cj=cjp3 pb=0.8049122 mj=0.3954951
+ cjsw=cjswp3 pbsw=0.8049122 mjsw=0.2573111
+ cjswg=cjswgp3 pbswg=0.8049122 mjswg=0.2573111
+ cgdo=cgop3 cgso=cgop3 tcj=0.0009940197
+ tcjsw=0.0006908749 tcjswg=0.0006908749 tpb=0.001625007
+ tpbsw=0.001625007 tpbswg=0.001625007 js=1.900e-07
+ jsw=1.00e-12 n=1 xti=3
+ capmod=3 nqsmod=0 xpart=1
+ cf=0 tlev=1 tlevc=1
+ llc=-0.0165
+ noimod=2 noia=2.0e19 noib=8.0e03
+ noic=5.4e-12 em=3.0e07 ef=1.094
+ minr=1e-60 imax=0.01 imelt=0.01

 11: type=p
+ lmin=5.000e-07 - dxlp3 lmax=1.200e-06 - dxlp3 wmin=5.0000e-07 - dxwp3
+ wmax=1.2000e-06 - dxwp3 tnom=25.0 version=3.24
+ tox=toxp3 toxm=6.77e-09 xj=1.7000001e-07
+ nch=4.9500000e17 lln=-1 lwn=1.0000000
+ wln=1.0000000 wwn=1.0000000 lint=3.5000000e-08
+ ll=0.00 lw=0.00 lwl=0.00
+ wint=2.0000000e-08 wl=0.00 ww=0.00
+ wwl=0.00 mobmod=1 binunit=2
+ xl= - 0.02e-6 + dxlp3 xw=0.0 + dxwp3 dwg=0.00
+ dwb=0.00 ldif=9.00e-08
+ hdif=hdifp3 rsh=rshp3 rd=0
+ rs=0 vth0= - 0.7239643 + dvthp3
+ lvth0=1.3674838e-08 + dlvthp3
+ wvth0=1.7082405e-08 + dwvthp3
+ pvth0= - 6.8885490e-15 + dpvthp3 k1=0.8600600
+ lk1=-4.8823770e-09 wk1=1.8429434e-09 pk1=1.0259654e-14
+ k2=7.5423550e-02 + dk2p3
+ lk2= - 3.3340390e-09 + dlk2p3 wk2=-3.2771350e-09
+ pk2=-1.7566433e-15 k3=0.00 dvt0=0.00
+ dvt1=0.00 dvt2=0.00 dvt0w=0.00
+ dvt1w=0.00 dvt2w=0.00 nlx=0.00
+ w0=0.00 k3b=0.00
+ vsat=1.2585714e05 + dvsatp3 wvsat=0 + dwvsatp3
+ lvsat=-6.5014090e-03 ua=2.9925082e-09 lua=-6.7682880e-16
+ wua=-1.1438922e-15 pua=3.0967882e-22 ub=-1.8703899e-19
+ lub=2.6311331e-25 wub=1.0903794e-25 pub=-1.2103212e-31
+ uc=-1.7420571e-10 luc=5.2762270e-17 wuc=-1.1744898e-17
+ puc=-1.6254219e-23 rdsw=9.0000000e02 prwb=0.00
+ prwg=0.00 wr=1.0000000 u0=1.5154593e-02 + du0p3
+ lu0= - 2.0351774e-09 + dlu0p3
+ wu0= - 2.9974716e-09 + dwu0p3
+ pu0=9.2253250e-16 + dpu0p3 a0=0.7949075
+ la0=4.7743620e-08 wa0=1.0154811e-07 pa0=-1.1553848e-14
+ keta=2.1075293e-02 lketa=-1.2696355e-08 wketa=-1.3982078e-09
+ pketa=7.8947390e-16 a1=0.00 a2=0.9900000
+ ags=2.3456581e-02 lags=-3.8010610e-10 wags=-4.0096360e-09
+ pags=4.4092310e-16 b0=0.00 b1=0.00
+ voff= - 0.1131885 + dvoffp3
+ lvoff= - 1.4584653e-09 + dlvoffp3
+ wvoff= - 2.8456701e-09 + dwvoffp3
+ pvoff=4.3249610e-15 + dpvoffp3
+ nfactor=1.0000000 + dnfactorp3 pnfactor=0 + dpnfactorp3
+ wnfactor=0 + dwnfactorp3 lnfactor=0 + dlnfactorp3
+ cit=4.4694590e-04 lcit=8.5205100e-12 wcit=2.0844531e-11
+ pcit=-2.3657607e-18 cdsc=0.00 cdscb=0.00
+ cdscd=0.00 eta0= - 4.2714290e-05 + deta0p3
+ peta0=0 + dpeta0p3 weta0=0 + dweta0p3
+ leta0=5.8512870e-11 + dleta0p3 etab=4.2714290e-05
+ letab=-5.8512870e-11 dsub=0.00 pclm=0.5728803
+ lpclm=5.2021480e-08 wpclm=4.4282560e-08 ppclm=-8.1762150e-15
+ pdiblc1=1.0000000e-06 pdiblc2=-5.6985730e-04 lpdiblc2=6.4364150e-10
+ pdiblcb=1.0000000e-02 drout=0.00 pscbe1=2.7071427e08
+ lpscbe1=32.5071400 pscbe2=5.0000000e-07 pvag=0.00
+ delta=1.0000000e-02 alpha0=0.00 alpha1=0.143217238
+ beta0=16.10832 kt1=-0.2933006 lkt1=-3.6994080e-09
+ wkt1=4.7625810e-09 pkt1=1.3560070e-15 kt2=-2.3266830e-02
+ lkt2=-3.4223340e-09 wkt2=-1.7626999e-09 pkt2=2.5675102e-15
+ at=-5.0000000e04 ute=-0.7077559 lute=7.6267040e-08
+ wute=5.0483580e-08 pute=-3.7703630e-15 ua1=2.1019217e-09
+ lua1=-2.9077913e-17 wua1=-8.2269240e-17 pua1=3.3730390e-23
+ ub1=-2.8656773e-18 lub1=3.3342050e-25 wub1=1.9451905e-25
+ pub1=-7.2403270e-32 uc1=7.5798370e-11 luc1=-1.1181404e-17
+ wuc1=1.1165895e-17 puc1=2.5759914e-24 kt1l=0.00
+ prt=0 cj=cjp3 pb=0.8049122
+ mj=0.3954951 cjsw=cjswp3 pbsw=0.8049122
+ mjsw=0.2573111 cjswg=cjswgp3 pbswg=0.8049122
+ mjswg=0.2573111 cgdo=cgop3 cgso=cgop3
+ tcj=0.0009940197 tcjsw=0.0006908749 tcjswg=0.0006908749
+ tpb=0.001625007 tpbsw=0.001625007 tpbswg=0.001625007
+ js=1.900e-07 jsw=1.00e-12 n=1
+ xti=3 capmod=3 nqsmod=0
+ xpart=1 cf=0 tlev=1
+ tlevc=1
+ llc=-0.0165 noimod=2 noia=2.0e19
+ noib=8.0e03 noic=5.4e-12 em=3.0e07
+ ef=1.094
+ minr=1e-60 imax=0.01 imelt=0.01

 12: type=p
+ lmin=3.0e-007 lmax=5.000e-07 - dxlp3 wmin=5.0000e-07 - dxwp3
+ wmax=1.2000e-06 - dxwp3 tnom=25.0 version=3.24
+ tox=toxp3 toxm=6.77e-09 xj=1.7000001e-07
+ nch=4.9500000e17 lln=-1 lwn=1.0000000
+ wln=1.0000000 wwn=1.0000000 lint=3.5000000e-08
+ ll=0.00 lw=0.00 lwl=0.00
+ wint=2.0000000e-08 wl=0.00 ww=0.00
+ wwl=0.00 mobmod=1 binunit=2
+ xl= - 0.02e-6 + dxlp3 xw=0.0 + dxwp3 dwg=0.00
+ dwb=0.00 ldif=9.00e-08
+ hdif=hdifp3 rsh=rshp3 rd=0
+ rs=0 vth0= - 0.7091326 + dvthp3
+ lvth0=7.5938330e-09 + dlvthp3
+ wvth0= - 1.8250328e-09 + dwvthp3
+ pvth0=8.6350020e-16 + dpvthp3 k1=0.7124246
+ lk1=5.5648150e-08 wk1=6.4895670e-08 pk1=-1.5591964e-14
+ k2=0.1203709 + dk2p3 lk2= - 2.1762434e-08 + dlk2p3
+ wk2=-1.4106020e-08 pk2=2.6832007e-15 k3=0.00
+ dvt0=0.00 dvt1=0.00 dvt2=0.00
+ dvt0w=0.00 dvt1w=0.00 dvt2w=0.00
+ nlx=0.00 w0=0.00 k3b=0.00
+ vsat=1.2733347e05 + dvsatp3 wvsat=0 + dwvsatp3
+ lvsat=-7.1067050e-03 ua=2.6204112e-09 lua=-5.2426900e-16
+ wua=-9.8327540e-16 pua=2.4382590e-22 ub=-1.5527859e-18
+ lub=8.2306960e-25 wub=7.3728160e-25 pub=-3.7861200e-31
+ uc=-2.3368188e-10 luc=7.7147500e-17 wuc=1.1670629e-17
+ puc=-2.5854586e-23 rdsw=9.0000000e02 prwb=0.00
+ prwg=0.00 wr=1.0000000 u0=1.0345819e-02 + du0p3
+ lu0= - 6.3580270e-11 + dlu0p3
+ wu0= - 9.3996030e-10 + dwu0p3
+ pu0=7.8952960e-17 + dpu0p3 a0=1.2442838
+ la0=-1.3650067e-07 wa0=2.7725269e-08 pa0=1.8713521e-14
+ keta=2.4851217e-04 lketa=-4.1573760e-09 wketa=8.3911840e-10
+ pketa=-1.2782924e-16 a1=0.00 a2=0.9900000
+ ags=2.2341035e-02 lags=7.7267680e-11 wags=-2.7156024e-09
+ pags=-8.9630500e-17 b0=0.00 b1=0.00
+ voff= - 0.1428125 + dvoffp3
+ lvoff=1.0687391e-08 + dlvoffp3
+ wvoff=1.9693728e-08 + dwvoffp3
+ pvoff= - 4.9161920e-15 + dpvoffp3
+ nfactor=1.0000000 + dnfactorp3 pnfactor=0 + dpnfactorp3
+ wnfactor=0 + dwnfactorp3 lnfactor=0 + dlnfactorp3
+ cit=4.0186070e-04 lcit=2.7005427e-11 wcit=2.5759807e-11
+ pcit=-4.3810230e-18 cdsc=0.00 cdscb=0.00
+ cdscd=0.00 eta0= - 5.9333350e-04 + deta0p3
+ peta0=0 + dpeta0p3 weta0=0 + dweta0p3
+ leta0=2.8426675e-10 + dleta0p3 etab=2.7869639e-04
+ letab=-1.5526558e-10 wetab=3.8393310e-10 petab=-1.5741254e-16
+ dsub=0.00 pclm=0.7490969 lpclm=-2.0227363e-08
+ wpclm=-5.8020430e-08 ppclm=3.3768010e-14 pdiblc1=1.0000000e-06
+ pdiblc2=1.0000000e-03 pdiblcb=1.0000000e-02 drout=0.00
+ pscbe1=3.1533334e08 lpscbe1=14.2133340 pscbe2=5.0000000e-07
+ pvag=0.00 delta=1.0000000e-02 alpha0=0.00
+ alpha1=0.143217238 beta0=16.10832 kt1=-0.3549937
+ lkt1=2.1594769e-08 wkt1=2.4955103e-08 pkt1=-6.9229260e-15
+ kt2=-4.3607630e-02 lkt2=4.9173970e-09 wkt2=1.5705877e-08
+ pkt2=-4.5946070e-15 at=-5.0000000e04 ute=-0.4699602
+ lute=-2.1229209e-08 wute=2.0363800e-08 pute=8.5787470e-15
+ ua1=2.0310000e-09 ub1=-1.9069588e-18 lub1=-5.9654050e-26
+ wub1=-1.4564585e-25 pub1=6.7064330e-32 uc1=1.1059081e-10
+ luc1=-2.5446301e-17 wuc1=-2.3868988e-17 puc1=1.6940293e-23
+ kt1l=0.00 prt=0 cj=cjp3
+ pb=0.8049122 mj=0.3954951 cjsw=cjswp3
+ pbsw=0.8049122 mjsw=0.2573111 cjswg=cjswgp3
+ pbswg=0.8049122 mjswg=0.2573111 cgdo=cgop3
+ cgso=cgop3 tcj=0.0009940197 tcjsw=0.0006908749
+ tcjswg=0.0006908749 tpb=0.001625007 tpbsw=0.001625007
+ tpbswg=0.001625007 js=1.900e-07 jsw=1.00e-12
+ n=1 xti=3 capmod=3
+ nqsmod=0 xpart=1 cf=0
+ tlev=1 tlevc=1
+ llc=-0.0165 noimod=2
+ noia=2.0e19 noib=8.0e03 noic=5.4e-12
+ em=3.0e07 ef=1.094
+ minr=1e-60 imax=0.01 imelt=0.01

 13: type=p
+ lmin=1.000e-05 - dxlp3 lmax=20.001e-006 wmin=2.2e-007
+ wmax=5.0000e-07 - dxwp3 tnom=25.0 version=3.24
+ tox=toxp3 toxm=6.77e-09 xj=1.7000001e-07
+ nch=4.9500000e17 lln=-1 lwn=1.0000000
+ wln=1.0000000 wwn=1.0000000 lint=3.5000000e-08
+ ll=0.00 lw=0.00 lwl=0.00
+ wint=2.0000000e-08 wl=0.00 ww=0.00
+ wwl=0.00 mobmod=1 binunit=2
+ xl= - 0.02e-6 + dxlp3 xw=0.0 + dxwp3 dwg=0.00
+ dwb=0.00 ldif=9.00e-08
+ hdif=hdifp3 rsh=rshp3 rd=0
+ rs=0 vth0= - 0.6974285 + dvthp3
+ pvth0=0 + dpvthp3 lvth0=0 + dlvthp3
+ wvth0=7.0971400e-09 + dwvthp3 k1=0.8440637
+ wk1=1.0907958e-08 k2=7.8954390e-02 + dk2p3
+ lk2=0 + dlk2p3 wk2=-5.0826280e-09 k3=0.00
+ dvt0=0.00 dvt1=0.00 dvt2=0.00
+ dvt0w=0.00 dvt1w=0.00 dvt2w=0.00
+ nlx=0.00 w0=0.00 k3b=0.00
+ vsat=1.5000002e05 + dvsatp3 wvsat=0 + dwvsatp3
+ ua=5.0500000e-10 ub=5.0000000e-20 uc=-1.3973826e-10
+ wuc=-1.8529287e-17 rdsw=9.0000000e02 prwb=0.00
+ prwg=0.00 wr=1.0000000 u0=7.9532350e-03 + du0p3
+ pu0=0 + dpu0p3 lu0=0 + dlu0p3
+ wu0=6.0421770e-10 + dwu0p3 a0=1.0130361
+ wa0=3.1547767e-08 keta=1.8505057e-02 wketa=-6.7609830e-10
+ a1=0.00 a2=0.9900000 ags=1.9999994e-02
+ b0=0.00 b1=0.00
+ voff= - 0.1076706 + dvoffp3 pvoff=0 + dpvoffp3
+ lvoff=0 + dlvoffp3 wvoff= - 2.1975590e-09 + dwvoffp3
+ nfactor=1.0000000 + dnfactorp3 pnfactor=0 + dpnfactorp3
+ wnfactor=0 + dwnfactorp3 lnfactor=0 + dlnfactorp3
+ cit=1.0026426e-03 wcit=-2.6414965e-10 cdsc=0.00
+ cdscb=0.00 cdscd=0.00
+ eta0=1.0000000e-05 + deta0p3 peta0=0 + dpeta0p3
+ weta0=0 + dweta0p3 leta0=0 + dleta0p3 etab=-1.0000000e-05
+ dsub=0.00 pclm=0.5000000 pdiblc1=1.0000000e-06
+ pdiblc2=1.0000000e-05 pdiblcb=1.0000000e-02 drout=0.00
+ pscbe1=2.0000003e08 pscbe2=5.0000000e-07 pvag=0.00
+ delta=1.0000000e-02 alpha0=0.00 alpha1=0.143217238
+ beta0=16.10832 kt1=-0.2896371 wkt1=2.8496747e-09
+ kt2=-2.7464394e-02 wkt2=1.0747162e-09 at=-5.0000000e04
+ ute=-0.6117741 wute=6.0315810e-09 ua1=2.0310005e-09
+ ub1=-2.7571342e-18 wub1=1.8899129e-25 uc1=6.2523140e-11
+ wuc1=-5.4885400e-18 kt1l=0.00 prt=0
+ cj=cjp3 pb=0.8049122 mj=0.3954951
+ cjsw=cjswp3 pbsw=0.8049122 mjsw=0.2573111
+ cjswg=cjswgp3 pbswg=0.8049122 mjswg=0.2573111
+ cgdo=cgop3 cgso=cgop3 tcj=0.0009940197
+ tcjsw=0.0006908749 tcjswg=0.0006908749 tpb=0.001625007
+ tpbsw=0.001625007 tpbswg=0.001625007 js=1.900e-07
+ jsw=1.00e-12 n=1 xti=3
+ capmod=3 nqsmod=0 xpart=1
+ cf=0 tlev=1 tlevc=1
+ llc=-0.0165
+ noimod=2 noia=2.0e19 noib=8.0e03
+ noic=5.4e-12 em=3.0e07 ef=1.094
+ minr=1e-60 imax=0.01 imelt=0.01

 14: type=p
+ lmin=1.200e-06 - dxlp3 lmax=1.000e-05 - dxlp3 wmin=2.2e-007
+ wmax=5.0000e-07 - dxwp3 tnom=25.0 version=3.24
+ tox=toxp3 toxm=6.77e-09 xj=1.7000001e-07
+ nch=4.9500000e17 lln=-1 lwn=1.0000000
+ wln=1.0000000 wwn=1.0000000 lint=3.5000000e-08
+ ll=0.00 lw=0.00 lwl=0.00
+ wint=2.0000000e-08 wl=0.00 ww=0.00
+ wwl=0.00 mobmod=1 binunit=2
+ xl= - 0.02e-6 + dxlp3 xw=0.0 + dxwp3 dwg=0.00
+ dwb=0.00 ldif=9.00e-08
+ hdif=hdifp3 rsh=rshp3 rd=0
+ rs=0 vth0= - 0.6969150 + dvthp3
+ lvth0= - 5.0894140e-09 + dlvthp3
+ wvth0=7.2090390e-09 + dwvthp3
+ pvth0= - 1.1089246e-15 + dpvthp3 k1=0.8422616
+ lk1=1.7858284e-08 wk1=1.1041521e-08 pk1=-1.3236105e-15
+ k2=7.9876470e-02 + dk2p3
+ lk2= - 9.1377870e-09 + dlk2p3 wk2=-5.1557550e-09
+ pk2=7.2469200e-16 k3=0.00 dvt0=0.00
+ dvt1=0.00 dvt2=0.00 dvt0w=0.00
+ dvt1w=0.00 dvt2w=0.00 nlx=0.00
+ w0=0.00 k3b=0.00
+ vsat=1.5378411e05 + dvsatp3 wvsat=0 + dwvsatp3
+ lvsat=-3.7500340e-02 ua=4.9978600e-10 lua=5.1669870e-17
+ wua=2.5417124e-18 pua=-2.5188352e-23 ub=5.0000000e-20
+ uc=-1.4113100e-10 luc=1.3801914e-17 wuc=-1.7655452e-17
+ puc=-8.6596870e-24 rdsw=9.0000000e02 prwb=0.00
+ prwg=0.00 wr=1.0000000 u0=8.0030420e-03 + du0p3
+ lu0= - 4.9358130e-10 + dlu0p3
+ wu0=6.1931930e-10 + dwu0p3
+ pu0= - 1.4965751e-16 + dpu0p3 a0=1.0128399
+ la0=1.9441604e-09 wa0=3.4282080e-08 pa0=-2.7097102e-14
+ keta=1.9746628e-02 lketa=-1.2303980e-08 wketa=-7.3130900e-10
+ pketa=5.4714090e-16 a1=0.00 a2=0.9900000
+ ags=1.4739780e-02 lags=5.2128610e-08 wags=2.6946623e-09
+ pags=-2.6704059e-14 b0=0.00 b1=0.00
+ voff= - 0.1071579 + dvoffp3
+ lvoff= - 5.0809350e-09 + dlvoffp3
+ wvoff= - 2.4467264e-09 + dwvoffp3
+ pvoff=2.4692497e-15 + dpvoffp3
+ nfactor=1.0000000 + dnfactorp3 pnfactor=0 + dpnfactorp3
+ wnfactor=0 + dwnfactorp3 lnfactor=0 + dlnfactorp3
+ cit=1.0682475e-03 lcit=-6.5014470e-10 wcit=-2.9820957e-10
+ pcit=3.3753370e-16 cdsc=0.00 cdscb=0.00
+ cdscd=0.00 eta0=1.0000000e-05 + deta0p3
+ peta0=0 + dpeta0p3 weta0=0 + dweta0p3 leta0=0 + dleta0p3
+ etab=-1.0000000e-05 dsub=0.00 pclm=0.4747727
+ lpclm=2.5000222e-07 pdiblc1=1.0000000e-06 pdiblc2=1.0000000e-05
+ pdiblcb=1.0000000e-02 drout=0.00 pscbe1=1.8738640e08
+ lpscbe1=1.2500110e02 pscbe2=5.0000000e-07 pvag=0.00
+ delta=1.0000000e-02 alpha0=0.00 alpha1=0.143217238
+ beta0=16.10832 kt1=-0.2892435 lkt1=-3.9008510e-09
+ wkt1=2.6791696e-09 pkt1=1.6897048e-15 kt2=-2.7126595e-02
+ lkt2=-3.3475660e-09 wkt2=9.2080900e-10 pkt2=1.5252189e-15
+ at=-5.0000000e04 ute=-0.6418697 lute=2.9824713e-07
+ wute=1.6279429e-08 pute=-1.0155609e-13 ua1=1.9554529e-09
+ lua1=7.4867650e-16 wua1=3.8701010e-17 pua1=-3.8352660e-22
+ ub1=-2.7104761e-18 lub1=-4.6238050e-25 wub1=1.6392816e-25
+ pub1=2.4837533e-31 uc1=6.1648940e-11 luc1=8.6633470e-18
+ wuc1=-7.6656470e-18 puc1=2.1575117e-23 kt1l=0.00
+ prt=0 cj=cjp3 pb=0.8049122
+ mj=0.3954951 cjsw=cjswp3 pbsw=0.8049122
+ mjsw=0.2573111 cjswg=cjswgp3 pbswg=0.8049122
+ mjswg=0.2573111 cgdo=cgop3 cgso=cgop3
+ tcj=0.0009940197 tcjsw=0.0006908749 tcjswg=0.0006908749
+ tpb=0.001625007 tpbsw=0.001625007 tpbswg=0.001625007
+ js=1.900e-07 jsw=1.00e-12 n=1
+ xti=3 capmod=3 nqsmod=0
+ xpart=1 cf=0 tlev=1
+ tlevc=1
+ llc=-0.0165 noimod=2 noia=2.0e19
+ noib=8.0e03 noic=5.4e-12 em=3.0e07
+ ef=1.094
+ minr=1e-60 imax=0.01 imelt=0.01

 15: type=p
+ lmin=5.000e-07 - dxlp3 lmax=1.200e-06 - dxlp3 wmin=2.2e-007
+ wmax=5.0000e-07 - dxwp3 tnom=25.0 version=3.24
+ tox=toxp3 toxm=6.77e-09 xj=1.7000001e-07
+ nch=4.9500000e17 lln=-1 lwn=1.0000000
+ wln=1.0000000 wwn=1.0000000 lint=3.5000000e-08
+ ll=0.00 lw=0.00 lwl=0.00
+ wint=2.0000000e-08 wl=0.00 ww=0.00
+ wwl=0.00 mobmod=1 binunit=2
+ xl= - 0.02e-6 + dxlp3 xw=0.0 + dxwp3 dwg=0.00
+ dwb=0.00 ldif=9.00e-08
+ hdif=hdifp3 rsh=rshp3 rd=0
+ rs=0 vth0= - 0.6988225 + dvthp3
+ lvth0= - 2.9720428e-09 + dlvthp3
+ wvth0=5.5172010e-09 + dwvthp3
+ pvth0=7.6901610e-16 + dpvthp3 k1=0.8387554
+ lk1=2.1750221e-08 wk1=1.1643079e-08 pk1=-1.9913423e-15
+ k2=7.7793220e-02 + dk2p3
+ lk2= - 6.8253770e-09 + dlk2p3 wk2=-4.3671790e-09
+ pk2=-1.5062782e-16 k3=0.00 dvt0=0.00
+ dvt1=0.00 dvt2=0.00 dvt0w=0.00
+ dvt1w=0.00 dvt2w=0.00 nlx=0.00
+ w0=0.00 k3b=0.00
+ vsat=1.2585714e05 + dvsatp3 wvsat=0 + dwvsatp3
+ lvsat=-6.5014080e-03 ua=5.4351430e-10 lua=3.1315486e-18
+ wua=-1.7355058e-17 pua=-3.1029357e-24 ub=5.0000000e-20
+ uc=-1.4399180e-10 luc=1.6977412e-17 wuc=-2.5643291e-17
+ puc=2.0681470e-25 rdsw=9.0000000e02 prwb=0.00
+ prwg=0.00 wr=1.0000000 u0=7.8093810e-03 + du0p3
+ lu0= - 2.7861857e-10 + dlu0p3
+ wu0=3.8132560e-10 + dwu0p3
+ pu0=1.1451548e-16 + dpu0p3 a0=1.0642401
+ la0=-5.5110040e-08 wa0=-2.2344880e-08 pa0=3.5758840e-14
+ keta=2.3581030e-02 lketa=-1.6560170e-08 wketa=-2.5508482e-09
+ pketa=2.5668300e-15 a1=0.00 a2=0.9900000
+ ags=6.6288150e-02 lags=-5.0900910e-09 wags=-2.3712159e-08
+ pags=2.6075162e-15 b0=0.00 b1=0.00
+ voff= - 0.1186088 + dvoffp3
+ lvoff=7.6296080e-09 + dlvoffp3
+ wvoff= - 3.5230960e-10 + dwvoffp3
+ pvoff=1.4444692e-16 + dpvoffp3
+ nfactor=1.0000000 + dnfactorp3 pnfactor=0 + dpnfactorp3
+ wnfactor=0 + dwnfactorp3 lnfactor=0 + dlnfactorp3
+ cit=4.5764680e-04 lcit=2.7622016e-11 wcit=1.5922081e-11
+ pcit=-1.1152456e-17 cdsc=0.00 cdscb=0.00
+ cdscd=0.00 eta0= - 4.2714270e-05 + deta0p3
+ peta0=0 + dpeta0p3 weta0=0 + dweta0p3
+ leta0=5.8512850e-11 + dleta0p3 etab=4.2714270e-05
+ letab=-5.8512850e-11 dsub=0.00 pclm=0.6980700
+ lpclm=2.1421234e-09 wpclm=-1.3304762e-08 ppclm=1.4768289e-14
+ pdiblc1=1.0000000e-06 pdiblc2=-5.6985720e-04 lpdiblc2=6.4364150e-10
+ pdiblcb=1.0000000e-02 drout=0.00 pscbe1=2.7071427e08
+ lpscbe1=32.5071400 pscbe2=5.0000000e-07 pvag=0.00
+ delta=1.0000000e-02 alpha0=0.00 alpha1=0.143217238
+ beta0=16.10832 kt1=-0.2975647 lkt1=5.3356430e-09
+ wkt1=6.7240530e-09 pkt1=-2.8001169e-15 kt2=-3.1370852e-02
+ lkt2=1.3635577e-09 wkt2=1.9651503e-09 pkt2=3.6600010e-16
+ at=-5.0000000e04 ute=-0.3558594 lute=-1.9224409e-08
+ wute=-1.1138885e-07 pute=4.0155710e-14 ua1=2.9807412e-09
+ lua1=-3.8939400e-16 wua1=-4.8652630e-16 pua1=1.9947582e-22
+ ub1=-3.6438770e-18 lub1=5.7369460e-25 wub1=5.5249090e-25
+ pub1=-1.8292942e-31 uc1=5.0477020e-11 luc1=2.1064192e-17
+ wuc1=2.2813721e-17 puc1=-1.2256985e-23 kt1l=0.00
+ prt=0 cj=cjp3 pb=0.8049122
+ mj=0.3954951 cjsw=cjswp3 pbsw=0.8049122
+ mjsw=0.2573111 cjswg=cjswgp3 pbswg=0.8049122
+ mjswg=0.2573111 cgdo=cgop3 cgso=cgop3
+ tcj=0.0009940197 tcjsw=0.0006908749 tcjswg=0.0006908749
+ tpb=0.001625007 tpbsw=0.001625007 tpbswg=0.001625007
+ js=1.900e-07 jsw=1.00e-12 n=1
+ xti=3 capmod=3 nqsmod=0
+ xpart=1 cf=0 tlev=1
+ tlevc=1
+ llc=-0.0165 noimod=2 noia=2.0e19
+ noib=8.0e03 noic=5.4e-12 em=3.0e07
+ ef=1.094
+ minr=1e-60 imax=0.01 imelt=0.01

 16: type=p
+ lmin=3.0e-007 lmax=5.000e-07 - dxlp3 wmin=2.2e-007
+ wmax=5.0000e-07 - dxwp3 tnom=25.0 version=3.24
+ tox=toxp3 toxm=6.77e-09 xj=1.7000001e-07
+ nch=4.9500000e17 lln=-1 lwn=1.0000000
+ wln=1.0000000 wwn=1.0000000 lint=3.5000000e-08
+ ll=0.00 lw=0.00 lwl=0.00
+ wint=2.0000000e-08 wl=0.00 ww=0.00
+ wwl=0.00 mobmod=1 binunit=2
+ xl= - 0.02e-6 + dxlp3 xw=0.0 + dxwp3 dwg=0.00
+ dwb=0.00 ldif=9.00e-08
+ hdif=hdifp3 rsh=rshp3 rd=0
+ rs=0 vth0= - 0.7102714 + dvthp3
+ lvth0=1.7220052e-09 + dlvthp3
+ wvth0= - 1.3011513e-09 + dwvthp3
+ pvth0=3.5645400e-15 + dpvthp3 k1=0.9896178
+ lk1=-4.0103360e-08 wk1=-6.2613200e-08 pk1=2.8453731e-14
+ k2=5.6198710e-02 + dk2p3
+ lk2=2.0283666e-09 + dlk2p3 wk2=1.5413164e-08
+ pk2=-8.2605680e-15 k3=0.00 dvt0=0.00
+ dvt1=0.00 dvt2=0.00 dvt0w=0.00
+ dvt1w=0.00 dvt2w=0.00 nlx=0.00
+ w0=0.00 k3b=0.00
+ vsat=1.2733347e05 + dvsatp3 wvsat=0 + dwvsatp3
+ lvsat=-7.1067050e-03 ua=5.6070820e-10 lua=-3.9179540e-18
+ wua=-3.5812070e-17 pua=4.4644360e-24 ub=5.0000000e-20
+ uc=-2.2165832e-10 luc=4.8820680e-17 wuc=6.1397940e-18
+ puc=-1.2824250e-23 rdsw=9.0000000e02 prwb=0.00
+ prwg=0.00 wr=1.0000000 u0=7.6553440e-03 + du0p3
+ lu0= - 2.1546345e-10 + dlu0p3
+ wu0=2.9765798e-10 + dwu0p3
+ pu0=1.4881922e-16 + dpu0p3 a0=1.2717079
+ la0=-1.4017188e-07 wa0=1.5110158e-08 pa0=2.0402271e-14
+ keta=-1.1058724e-02 lketa=-2.3578717e-09 wketa=6.0404470e-09
+ pketa=-9.5560120e-16 a1=0.00 a2=0.9900000
+ ags=5.1349650e-02 lags=1.0346969e-09 wags=-1.6059564e-08
+ pags=-5.3004870e-16 b0=0.00 b1=0.00
+ voff= - 0.1000001 + dvoffp3 pvoff=0 + dpvoffp3
+ wvoff=0 + dwvoffp3 lvoff=0 + dlvoffp3
+ nfactor=1.0000000 + dnfactorp3 pnfactor=0 + dpnfactorp3
+ wnfactor=0 + dwnfactorp3 lnfactor=0 + dlnfactorp3
+ cit=5.0953650e-04 lcit=6.3472730e-12 wcit=-2.3771051e-11
+ pcit=5.1217290e-18 cdsc=0.00 cdscb=0.00
+ cdscd=0.00 eta0= - 5.9333330e-04 + deta0p3
+ peta0=0 + dpeta0p3 weta0=0 + dweta0p3
+ leta0=2.8426667e-10 + dleta0p3 etab=1.1133335e-03
+ letab=-4.9746670e-10 dsub=0.00 pclm=0.9552779
+ lpclm=-1.0331307e-07 wpclm=-1.5286366e-07 ppclm=7.1987430e-14
+ pdiblc1=1.0000000e-06 pdiblc2=1.0000000e-03 pdiblcb=1.0000000e-02
+ drout=0.00 pscbe1=3.1533334e08 lpscbe1=14.2133340
+ pscbe2=5.0000000e-07 pvag=0.00 delta=1.0000000e-02
+ alpha0=0.00 alpha1=0.143217238 beta0=16.10832
+ kt1=-0.2914546 lkt1=2.8305438e-09 wkt1=-4.2728600e-09
+ pkt1=1.7086176e-15 kt2=-2.2502899e-02 lkt2=-2.2723026e-09
+ wkt2=5.9977000e-09 pkt2=-1.2873453e-15 at=-5.0000000e04
+ ute=-0.4071587 lute=1.8082899e-09 wute=-8.5249080e-09
+ pute=-2.0185026e-15 ua1=2.0309998e-09 ub1=-2.3083980e-18
+ lub1=2.6148351e-26 wub1=3.9016210e-26 pub1=2.7595218e-32
+ uc1=1.0124479e-10 luc1=2.4940948e-19 wuc1=-1.9569818e-17
+ puc1=5.1202650e-24 kt1l=0.00 prt=0
+ cj=cjp3 pb=0.8049122 mj=0.3954951
+ cjsw=cjswp3 pbsw=0.8049122 mjsw=0.2573111
+ cjswg=cjswgp3 pbswg=0.8049122 mjswg=0.2573111
+ cgdo=cgop3 cgso=cgop3 tcj=0.0009940197
+ tcjsw=0.0006908749 tcjswg=0.0006908749 tpb=0.001625007
+ tpbsw=0.001625007 tpbswg=0.001625007 js=1.900e-07
+ jsw=1.00e-12 n=1 xti=3
+ capmod=3 nqsmod=0 xpart=1
+ cf=0 tlev=1 tlevc=1
+ llc=-0.0165
+ noimod=2 noia=2.0e19 noib=8.0e03
+ noic=5.4e-12 em=3.0e07 ef=1.094
+ minr=1e-60 imax=0.01 imelt=0.01

     }

subckt nch3_mis ( d g s b )
parameters l=35.e-08 w=1.5e-6 multi=1 ad=2*hdifn3*w as=2*hdifn3*w pd=2*(2*hdifn3+w) ps=2*(2*hdifn3+w) nrd=hdifn3/w nrs=hdifn3/w
+ lef=l - 20e-9 wef=w geo_fac=1 / sqrt(multi
+ * lef * wef * 1e12) vthmis=6.227e-3 * geo_fac * vthnmis3 dlmis=3.65e-3 * geo_fac
+ * lef * dlnmis3 dwmis=2.98e-3 * geo_fac * wef * dwnmis3 toxmis=8.04e-4 * geo_fac
+ * toxn3 * toxnmis3
m0 ( d g s b ) nch3mis w=w l=l ad=ad as=as pd=pd ps=ps nrd=nrd nrs=nrs m=multi

model nch3mis bsim3v3  {
     1: type=n
+ lmin=1.000e-05-dxln3-dlmis                          lmax=20.001e-006
+ wmin=1.0000e-05-dxwn3-dwmis                         wmax=900.001e-6
+ tnom=25.0                 version=3.24              tox=toxn3+toxmis
+ toxm=6.8e-09              xj=1.7000001e-07          nch=5.2600000e17
+ lln=-1                    lwn=1.0000000             wln=1.0000000
+ wwn=1.0000000             lint=4.0000000e-08        ll=0.00
+ lw=0.00                   lwl=0.00                  wint=1.4999999e-08
+ wl=0.00                   ww=0.00                   wwl=0.00
+ mobmod=1                  binunit=2                 xl=-0.02e-6+dxln3+dlmis
+ xw=0.0+dxwn3+dwmis        dwg=0.00                  dwb=0.00
+ ldif=9.00e-08             hdif=hdifn3               rsh=rshn3
+ rd=0                      rs=0                      vth0=0.7411730+dvthn3+vthmis
+ pvth0=0+dpvthn3           wvth0=0+dwvthn3           lvth0=0+dlvthn3
+ k1=0.8520129              k2=3.2049370e-02+dk2n3    lk2=0+dlk2n3
+ k3=0.00                   dvt0=0.00                 dvt1=0.00
+ dvt2=0.00                 dvt0w=0.00                dvt1w=0.00
+ dvt2w=0.00                nlx=0.00                  w0=0.00
+ k3b=0.00                  vsat=1.0000000e05+dvsatn3 wvsat=0+dwvsatn3
+ ua=-6.5967100e-10         ub=2.3514212e-18          uc=1.0151108e-10
+ rdsw=5.4500000e02         prwb=0.00                 prwg=0.00
+ wr=1.0000000              u0=4.0383610e-02+du0n3    pu0=0+dpu0n3
+ wu0=0+dwu0n3              lu0=0+dlu0n3              a0=0.5957787
+ keta=1.0636362e-02        a1=0.00                   a2=0.9900000
+ ags=2.0000000e-02         b0=0.00                   b1=0.00
+ voff=-0.1273081+dvoffn3   pvoff=0+dpvoffn3          wvoff=0+dwvoffn3
+ lvoff=0+dlvoffn3          nfactor=1.0000000+dnfactorn3
+ pnfactor=0+dpnfactorn3    wnfactor=0+dwnfactorn3    lnfactor=0+dlnfactorn3
+ cit=3.2298330e-04         cdsc=0.00                 cdscb=0.00
+ cdscd=0.00                eta0=1.0000000e-05+deta0n3
+ peta0=0+dpeta0n3          weta0=0+dweta0n3          leta0=0+dleta0n3
+ etab=-1.0000000e-05       dsub=0.00                 pclm=0.5000001
+ pdiblc1=1.0000000e-06     pdiblc2=5.0000000e-04     pdiblcb=1.0000000e-02
+ drout=0.00                pscbe1=2.0000000e08       pscbe2=1.0000000e-06
+ pvag=0.00                 delta=1.0000000e-02       alpha0=0.0
+ alpha1=7.049416           beta0=21.5673             kt1=-0.2967474
+ kt2=-3.0051107e-02        at=2.0000000e04           ute=-1.3699325
+ ua1=2.0399999e-09         ub1=-2.3240355e-18        uc1=-2.5228651e-11
+ kt1l=0.00                 prt=0                     cj=cjn3
+ pb=0.7076023              mj=0.3259624              cjsw=cjswn3
+ pbsw=0.7076023            mjsw=0.1513672            cjswg=cjswgn3
+ pbswg=0.7076023           mjswg=0.3513672           cgdo=cgon3
+ cgso=cgon3                tcj=0.0009923959          tcjsw=0.0005019466
+ tcjswg=0.0005019466       tpb=0.001687207           tpbsw=0.001687207
+ tpbswg=0.001687207        js=3.93e-07               jsw=1.43e-12
+ n=1                       xti=3                     capmod=3
+ nqsmod=0                  xpart=1                   cf=0
+ tlev=1                    tlevc=1                   llc=-0.0165
+ noimod=2                  noia=1.0e20               noib=4.0e04
+ noic=-4.0e-13             em=3.0e07                 ef=0.881
+ minr=1e-60                imax=0.01                 imelt=0.01

     2: type=n
+ lmin=1.200e-06-dxln3-dlmis                          lmax=1.000e-05-dxln3-dlmis
+ wmin=1.0000e-05-dxwn3-dwmis                         wmax=900.001e-6
+ tnom=25.0                 version=3.24              tox=toxn3+toxmis
+ toxm=6.8e-09              xj=1.7000001e-07          nch=5.2600000e17
+ lln=-1                    lwn=1.0000000             wln=1.0000000
+ wwn=1.0000000             lint=4.0000000e-08        ll=0.00
+ lw=0.00                   lwl=0.00                  wint=1.4999999e-08
+ wl=0.00                   ww=0.00                   wwl=0.00
+ mobmod=1                  binunit=2                 xl=-0.02e-6+dxln3+dlmis
+ xw=0.0+dxwn3+dwmis        dwg=0.00                  dwb=0.00
+ ldif=9.00e-08             hdif=hdifn3               rsh=rshn3
+ rd=0                      rs=0                      vth0=0.7338805+dvthn3+vthmis
+ pvth0=0+dpvthn3           wvth0=0+dwvthn3           lvth0=7.2196430e-08+dlvthn3
+ k1=0.8436294              lk1=8.2996260e-08         k2=3.5836430e-02+dk2n3
+ lk2=-3.7491980e-08+dlk2n3 k3=0.00                   dvt0=0.00
+ dvt1=0.00                 dvt2=0.00                 dvt0w=0.00
+ dvt1w=0.00                dvt2w=0.00                nlx=0.00
+ w0=0.00                   k3b=0.00                  vsat=1.0087500e05+dvsatn3
+ wvsat=0+dwvsatn3          lvsat=-8.6625000e-03      ua=-6.5715190e-10
+ lua=-2.4938983e-17        ub=2.3501459e-18          lub=1.2625015e-26
+ uc=9.9987010e-11          luc=1.5088319e-17         rdsw=5.4500000e02
+ prwb=0.00                 prwg=0.00                 wr=1.0000000
+ u0=4.0144190e-02+du0n3    pu0=0+dpu0n3              wu0=0+dwu0n3
+ lu0=2.3703481e-09+dlu0n3  a0=0.5985498              la0=-2.7434131e-08
+ keta=1.3293392e-02        lketa=-2.6304601e-08      a1=0.00
+ a2=0.9900000              ags=2.0000000e-02         b0=0.00
+ b1=0.00                   voff=-0.1288763+dvoffn3   pvoff=0+dpvoffn3
+ wvoff=0+dwvoffn3          lvoff=1.5525753e-08+dlvoffn3
+ nfactor=1.0000000+dnfactorn3                        pnfactor=0+dpnfactorn3
+ wnfactor=0+dwnfactorn3    lnfactor=0+dlnfactorn3    cit=2.9848100e-04
+ lcit=2.4257210e-10        cdsc=0.00                 cdscb=0.00
+ cdscd=0.00                eta0=5.0055810e-06+deta0n3
+ peta0=0+dpeta0n3          weta0=0+dweta0n3          leta0=4.9444760e-11+dleta0n3
+ etab=-5.0055810e-06       letab=-4.9444760e-11      dsub=0.00
+ pclm=0.4766459            lpclm=2.3120668e-07       pdiblc1=1.0000000e-06
+ pdiblc2=4.3750000e-04     lpdiblc2=6.1875000e-10    pdiblcb=1.0000000e-02
+ drout=0.00                pscbe1=1.8500000e08       lpscbe1=1.4850000e02
+ pscbe2=1.0000000e-06      pvag=0.00                 delta=1.0000000e-02
+ alpha0=0.0                alpha1=7.049416           beta0=21.5673
+ kt1=-0.2975682            lkt1=8.1267750e-09        kt2=-3.0177854e-02
+ lkt2=1.2547903e-09        at=2.0000000e04           ute=-1.3824263
+ lute=1.2368807e-07        ua1=2.0399999e-09         ub1=-2.3458511e-18
+ lub1=2.1597545e-25        uc1=-2.8060729e-11        luc1=2.8037565e-17
+ kt1l=0.00                 prt=0                     cj=cjn3
+ pb=0.7076023              mj=0.3259624              cjsw=cjswn3
+ pbsw=0.7076023            mjsw=0.1513672            cjswg=cjswgn3
+ pbswg=0.7076023           mjswg=0.3513672           cgdo=cgon3
+ cgso=cgon3                tcj=0.0009923959          tcjsw=0.0005019466
+ tcjswg=0.0005019466       tpb=0.001687207           tpbsw=0.001687207
+ tpbswg=0.001687207        js=3.93e-07               jsw=1.43e-12
+ n=1                       xti=3                     capmod=3
+ nqsmod=0                  xpart=1                   cf=0
+ tlev=1                    tlevc=1                   llc=-0.0165
+ noimod=2                  noia=1.0e20               noib=4.0e04
+ noic=-4.0e-13             em=3.0e07                 ef=0.881
+ minr=1e-60                imax=0.01                 imelt=0.01

     3: type=n
+ lmin=5.000e-07-dxln3-dlmis                          lmax=1.200e-06-dxln3-dlmis
+ wmin=1.0000e-05-dxwn3-dwmis                         wmax=900.001e-6
+ tnom=25.0                 version=3.24              tox=toxn3+toxmis
+ toxm=6.8e-09              xj=1.7000001e-07          nch=5.2600000e17
+ lln=-1                    lwn=1.0000000             wln=1.0000000
+ wwn=1.0000000             lint=4.0000000e-08        ll=0.00
+ lw=0.00                   lwl=0.00                  wint=1.4999999e-08
+ wl=0.00                   ww=0.00                   wwl=0.00
+ mobmod=1                  binunit=2                 xl=-0.02e-6+dxln3+dlmis
+ xw=0.0+dxwn3+dwmis        dwg=0.00                  dwb=0.00
+ ldif=9.00e-08             hdif=hdifn3               rsh=rshn3
+ rd=0                      rs=0                      vth0=0.7854808+dvthn3+vthmis
+ pvth0=0+dpvthn3           wvth0=0+dwvthn3           lvth0=1.5436049e-08+dlvthn3
+ k1=0.8725621              lk1=5.1170270e-08         k2=2.6585609e-02+dk2n3
+ lk2=-2.7316075e-08+dlk2n3 k3=0.00                   dvt0=0.00
+ dvt1=0.00                 dvt2=0.00                 dvt0w=0.00
+ dvt1w=0.00                dvt2w=0.00                nlx=0.00
+ w0=0.00                   k3b=0.00                  vsat=9.4142860e04+dvsatn3
+ wvsat=0+dwvsatn3          lvsat=-1.2571429e-03      ua=-5.5044020e-10
+ lua=-1.4232186e-16        ub=2.2213255e-18          lub=1.5432739e-25
+ uc=8.6765090e-11          luc=2.9632438e-17         rdsw=5.4500000e02
+ prwb=0.00                 prwg=0.00                 wr=1.0000000
+ u0=4.1177810e-02+du0n3    pu0=0+dpu0n3              wu0=0+dwu0n3
+ lu0=1.2333661e-09+dlu0n3  a0=0.5002358              la0=8.0711320e-08
+ keta=3.0733263e-03        lketa=-1.5062529e-08      a1=0.00
+ a2=0.9900000              ags=4.2857150e-02         lags=-2.5142864e-08
+ b0=0.00                   b1=0.00                   voff=-0.1181122+dvoffn3
+ pvoff=0+dpvoffn3          wvoff=0+dwvoffn3          lvoff=3.6851710e-09+dlvoffn3
+ nfactor=1.0000000+dnfactorn3                        pnfactor=0+dpnfactorn3
+ wnfactor=0+dwnfactorn3    lnfactor=0+dlnfactorn3    cit=5.2695760e-04
+ lcit=-8.7521730e-12       cdsc=0.00                 cdscb=0.00
+ cdscd=0.00                eta0=-2.0721287e-04+deta0n3
+ peta0=0+dpeta0n3          weta0=0+dweta0n3          leta0=2.8288508e-10+dleta0n3
+ etab=2.0721287e-04        letab=-2.8288508e-10      dsub=0.00
+ pclm=0.6683022            lpclm=2.0384716e-08       pdiblc1=1.0000000e-06
+ pdiblc2=9.9999980e-04     pdiblcb=1.0000000e-02     drout=0.00
+ pscbe1=3.0285712e08       lpscbe1=18.8571820        pscbe2=1.0000000e-06
+ pvag=0.00                 delta=1.0000000e-02       alpha0=0.0
+ alpha1=7.049416           beta0=21.5673             kt1=-0.3058816
+ lkt1=1.7271480e-08        kt2=-3.2605510e-02        lkt2=3.9252180e-09
+ at=2.0000000e04           ute=-1.3841497            lute=1.2558385e-07
+ ua1=2.0399999e-09         ub1=-2.6782768e-18        lub1=5.8164370e-25
+ uc1=-7.4947920e-11        luc1=7.9613470e-17        kt1l=0.00
+ prt=0                     cj=cjn3                   pb=0.7076023
+ mj=0.3259624              cjsw=cjswn3               pbsw=0.7076023
+ mjsw=0.1513672            cjswg=cjswgn3             pbswg=0.7076023
+ mjswg=0.3513672           cgdo=cgon3                cgso=cgon3
+ tcj=0.0009923959          tcjsw=0.0005019466        tcjswg=0.0005019466
+ tpb=0.001687207           tpbsw=0.001687207         tpbswg=0.001687207
+ js=3.93e-07               jsw=1.43e-12              n=1
+ xti=3                     capmod=3                  nqsmod=0
+ xpart=1                   cf=0                      tlev=1
+ tlevc=1                   llc=-0.0165               noimod=2
+ noia=1.0e20               noib=4.0e04               noic=-4.0e-13
+ em=3.0e07                 ef=0.881                  minr=1e-60
+ imax=0.01                 imelt=0.01

     4: type=n
+ lmin=3.5e-007             lmax=5.000e-07-dxln3-dlmis
+ wmin=1.0000e-05-dxwn3-dwmis                         wmax=900.001e-6
+ tnom=25.0                 version=3.24              tox=toxn3+toxmis
+ toxm=6.8e-09              xj=1.7000001e-07          nch=5.2600000e17
+ lln=-1                    lwn=1.0000000             wln=1.0000000
+ wwn=1.0000000             lint=4.0000000e-08        ll=0.00
+ lw=0.00                   lwl=0.00                  wint=1.4999999e-08
+ wl=0.00                   ww=0.00                   wwl=0.00
+ mobmod=1                  binunit=2                 xl=-0.02e-6+dxln3+dlmis
+ xw=0.0+dxwn3+dwmis        dwg=0.00                  dwb=0.00
+ ldif=9.00e-08             hdif=hdifn3               rsh=rshn3
+ rd=0                      rs=0                      vth0=0.8656338+dvthn3+vthmis
+ pvth0=0+dpvthn3           wvth0=0+dwvthn3           lvth0=-1.6625165e-08+dlvthn3
+ k1=0.7380362              lk1=1.0498064e-07         k2=0.1905548+dk2n3
+ lk2=-9.2903750e-08+dlk2n3 k3=0.00                   dvt0=0.00
+ dvt1=0.00                 dvt2=0.00                 dvt0w=0.00
+ dvt1w=0.00                dvt2w=0.00                nlx=0.00
+ w0=0.00                   k3b=0.00                  vsat=9.2662950e04+dvsatn3
+ wvsat=0+dwvsatn3          lvsat=-6.6517710e-04      ua=-7.6742930e-10
+ lua=-5.5526210e-17        ub=2.1708317e-18          lub=1.7452491e-25
+ uc=2.5100996e-10          luc=-3.6065510e-17        rdsw=5.4500000e02
+ prwb=0.00                 prwg=0.00                 wr=1.0000000
+ u0=4.2647680e-02+du0n3    pu0=0+dpu0n3              wu0=0+dwu0n3
+ lu0=6.4541630e-10+dlu0n3  a0=0.8895671              la0=-7.5021190e-08
+ keta=-5.8208280e-02       lketa=9.4501150e-09       a1=0.00
+ a2=0.9900000              ags=-2.0000029e-02        b0=0.00
+ b1=0.00                   voff=-0.1009514+dvoffn3   pvoff=0+dpvoffn3
+ wvoff=0+dwvoffn3          lvoff=-3.1791380e-09+dlvoffn3
+ nfactor=1.0000000+dnfactorn3                        pnfactor=0+dpnfactorn3
+ wnfactor=0+dwnfactorn3    lnfactor=0+dlnfactorn3    cit=4.9120500e-04
+ lcit=5.5488980e-12        cdsc=0.00                 cdscb=0.00
+ cdscd=0.00                eta0=-1.1666669e-03+deta0n3
+ peta0=0+dpeta0n3          weta0=0+dweta0n3          leta0=6.6666670e-10+dleta0n3
+ etab=3.6657390e-03        letab=-1.6662953e-09      dsub=0.00
+ pclm=-0.1426817           lpclm=3.4477830e-07       pdiblc1=1.0000000e-06
+ pdiblc2=-1.0661089e-02    lpdiblc2=4.6644360e-09    pdiblcb=1.0000000e-02
+ drout=0.00                pscbe1=3.5000020e08       pscbe2=1.0000000e-06
+ pvag=0.00                 delta=1.0000000e-02       alpha0=0.0
+ alpha1=7.049416           beta0=21.5673             kt1=-0.2689408
+ lkt1=2.4951499e-09        kt2=-1.7957341e-02        lkt2=-1.9340516e-09
+ at=2.0000000e04           ute=-1.0052726            lute=-2.5966962e-08
+ ua1=2.0399999e-09         ub1=-1.6034720e-18        lub1=1.5172175e-25
+ uc1=9.0686240e-11         luc1=1.3359813e-17        kt1l=0.00
+ prt=0                     cj=cjn3                   pb=0.7076023
+ mj=0.3259624              cjsw=cjswn3               pbsw=0.7076023
+ mjsw=0.1513672            cjswg=cjswgn3             pbswg=0.7076023
+ mjswg=0.3513672           cgdo=cgon3                cgso=cgon3
+ tcj=0.0009923959          tcjsw=0.0005019466        tcjswg=0.0005019466
+ tpb=0.001687207           tpbsw=0.001687207         tpbswg=0.001687207
+ js=3.93e-07               jsw=1.43e-12              n=1
+ xti=3                     capmod=3                  nqsmod=0
+ xpart=1                   cf=0                      tlev=1
+ tlevc=1                   llc=-0.0165               noimod=2
+ noia=1.0e20               noib=4.0e04               noic=-4.0e-13
+ em=3.0e07                 ef=0.881                  minr=1e-60
+ imax=0.01                 imelt=0.01

     5: type=n
+ lmin=1.000e-05-dxln3-dlmis                          lmax=20.001e-006
+ wmin=1.2000e-06-dxwn3-dwmis                         wmax=1.0000e-05-dxwn3-dwmis
+ tnom=25.0                 version=3.24              tox=toxn3+toxmis
+ toxm=6.8e-09              xj=1.7000001e-07          nch=5.2600000e17
+ lln=-1                    lwn=1.0000000             wln=1.0000000
+ wwn=1.0000000             lint=4.0000000e-08        ll=0.00
+ lw=0.00                   lwl=0.00                  wint=1.4999999e-08
+ wl=0.00                   ww=0.00                   wwl=0.00
+ mobmod=1                  binunit=2                 xl=-0.02e-6+dxln3+dlmis
+ xw=0.0+dxwn3+dwmis        dwg=0.00                  dwb=0.00
+ ldif=9.00e-08             hdif=hdifn3               rsh=rshn3
+ rd=0                      rs=0                      vth0=0.7412278+dvthn3+vthmis
+ pvth0=0+dpvthn3           lvth0=0+dlvthn3           wvth0=-5.4619160e-10+dwvthn3
+ k1=0.8508129              wk1=1.1963754e-08         k2=3.1879250e-02+dk2n3
+ lk2=0+dlk2n3              wk2=1.6960789e-09         k3=0.00
+ dvt0=0.00                 dvt1=0.00                 dvt2=0.00
+ dvt0w=0.00                dvt1w=0.00                dvt2w=0.00
+ nlx=0.00                  w0=0.00                   k3b=0.00
+ vsat=1.0000000e05+dvsatn3 wvsat=0+dwvsatn3          ua=-6.5888360e-10
+ wua=-7.8505910e-18        ub=2.3875394e-18          wub=-3.6009940e-25
+ uc=1.0341122e-10          wuc=-1.8944324e-17        rdsw=5.4500000e02
+ prwb=0.00                 prwg=0.00                 wr=1.0000000
+ u0=4.0690960e-02+du0n3    pu0=0+dpu0n3              lu0=0+dlu0n3
+ wu0=-3.0642096e-09+dwu0n3 a0=0.5914139              wa0=4.3517560e-08
+ keta=1.0701262e-02        wketa=-6.4705320e-10      a1=0.00
+ a2=0.9900000              ags=2.0000000e-02         b0=0.00
+ b1=0.00                   voff=-0.1275286+dvoffn3   pvoff=0+dpvoffn3
+ lvoff=0+dlvoffn3          wvoff=2.1983364e-09+dwvoffn3
+ nfactor=1.0000000+dnfactorn3                        pnfactor=0+dpnfactorn3
+ wnfactor=0+dwnfactorn3    lnfactor=0+dlnfactorn3    cit=3.2352310e-04
+ wcit=-5.3825510e-12       cdsc=0.00                 cdscb=0.00
+ cdscd=0.00                eta0=1.0000000e-05+deta0n3
+ peta0=0+dpeta0n3          weta0=0+dweta0n3          leta0=0+dleta0n3
+ etab=-1.0000000e-05       dsub=0.00                 pclm=0.5000001
+ pdiblc1=1.0000000e-06     pdiblc2=5.0000000e-04     pdiblcb=1.0000000e-02
+ drout=0.00                pscbe1=2.0000000e08       pscbe2=1.0000000e-06
+ pvag=0.00                 delta=1.0000000e-02       alpha0=0.0
+ alpha1=7.049416           beta0=21.5673             kt1=-0.2959924
+ wkt1=-7.5268250e-09       kt2=-2.9950516e-02        wkt2=-1.0028854e-09
+ at=2.0000000e04           ute=-1.3781972            wute=8.2399010e-08
+ ua1=2.0399999e-09         ub1=-2.3223396e-18        wub1=-1.6908192e-26
+ uc1=-1.9919816e-11        wuc1=-5.2929100e-17       kt1l=0.00
+ prt=0                     cj=cjn3                   pb=0.7076023
+ mj=0.3259624              cjsw=cjswn3               pbsw=0.7076023
+ mjsw=0.1513672            cjswg=cjswgn3             pbswg=0.7076023
+ mjswg=0.3513672           cgdo=cgon3                cgso=cgon3
+ tcj=0.0009923959          tcjsw=0.0005019466        tcjswg=0.0005019466
+ tpb=0.001687207           tpbsw=0.001687207         tpbswg=0.001687207
+ js=3.93e-07               jsw=1.43e-12              n=1
+ xti=3                     capmod=3                  nqsmod=0
+ xpart=1                   cf=0                      tlev=1
+ tlevc=1                   llc=-0.0165               noimod=2
+ noia=1.0e20               noib=4.0e04               noic=-4.0e-13
+ em=3.0e07                 ef=0.881                  minr=1e-60
+ imax=0.01                 imelt=0.01

     6: type=n
+ lmin=1.200e-06-dxln3-dlmis                          lmax=1.000e-05-dxln3-dlmis
+ wmin=1.2000e-06-dxwn3-dwmis                         wmax=1.0000e-05-dxwn3-dwmis
+ tnom=25.0                 version=3.24              tox=toxn3+toxmis
+ toxm=6.8e-09              xj=1.7000001e-07          nch=5.2600000e17
+ lln=-1                    lwn=1.0000000             wln=1.0000000
+ wwn=1.0000000             lint=4.0000000e-08        ll=0.00
+ lw=0.00                   lwl=0.00                  wint=1.4999999e-08
+ wl=0.00                   ww=0.00                   wwl=0.00
+ mobmod=1                  binunit=2                 xl=-0.02e-6+dxln3+dlmis
+ xw=0.0+dxwn3+dwmis        dwg=0.00                  dwb=0.00
+ ldif=9.00e-08             hdif=hdifn3               rsh=rshn3
+ rd=0                      rs=0                      vth0=0.7337149+dvthn3+vthmis
+ lvth0=7.4378140e-08+dlvthn3                         wvth0=1.6509301e-09+dwvthn3
+ pvth0=-2.1751505e-14+dpvthn3                        k1=0.8419480
+ lk1=8.7762780e-08         wk1=1.6763977e-08         pk1=-4.7522210e-14
+ k2=3.5826360e-02+dk2n3    lk2=-3.9076370e-08+dlk2n3 wk2=1.0048508e-10
+ pk2=1.5796389e-14         k3=0.00                   dvt0=0.00
+ dvt1=0.00                 dvt2=0.00                 dvt0w=0.00
+ dvt1w=0.00                dvt2w=0.00                nlx=0.00
+ w0=0.00                   k3b=0.00                  vsat=1.0087500e05+dvsatn3
+ wvsat=0+dwvsatn3          lvsat=-8.6625010e-03      ua=-6.5616190e-10
+ lua=-2.6944907e-17        wua=-9.8707010e-18        pua=1.9999060e-23
+ ub=2.3849762e-18          lub=2.5376364e-26         wub=-3.4725790e-25
+ pub=-1.2713090e-31        uc=1.0178221e-10          luc=1.6127195e-17
+ wuc=-1.7898101e-17        puc=-1.0357598e-23        rdsw=5.4500000e02
+ prwb=0.00                 prwg=0.00                 wr=1.0000000
+ u0=4.0439300e-02+du0n3    lu0=2.4913751e-09+dlu0n3  wu0=-2.9423268e-09+dwu0n3
+ pu0=-1.2066391e-15+dpu0n3 a0=0.5931649              la0=-1.7334720e-08
+ wa0=5.3688390e-08         pa0=-1.0069116e-13        keta=1.3365778e-02
+ lketa=-2.6378700e-08      wketa=-7.2167630e-10      pketa=7.3875800e-16
+ a1=0.00                   a2=0.9900000              ags=2.0000000e-02
+ b0=0.00                   b1=0.00                   voff=-0.1290965+dvoffn3
+ lvoff=1.5522346e-08+dlvoffn3                        wvoff=2.1949056e-09+dwvoffn3
+ pvoff=3.3964270e-17+dpvoffn3                        nfactor=1.0000000+dnfactorn3
+ pnfactor=0+dpnfactorn3    wnfactor=0+dwnfactorn3    lnfactor=0+dlnfactorn3
+ cit=2.9909017e-04         lcit=2.4188637e-10        wcit=-6.0731490e-12
+ pcit=6.8368810e-18        cdsc=0.00                 cdscb=0.00
+ cdscd=0.00                eta0=4.3415470e-06+deta0n3
+ leta0=5.6018670e-11+dleta0n3                        weta0=6.6203900e-12+dweta0n3
+ peta0=-6.5541850e-17+dpeta0n3                       etab=-4.3415470e-06
+ letab=-5.6018670e-11      wetab=-6.6203900e-12      petab=6.5541850e-17
+ dsub=0.00                 pclm=0.4771902            lpclm=2.2581794e-07
+ wpclm=-5.4269150e-09      ppclm=5.3725680e-14       pdiblc1=1.0000000e-06
+ pdiblc2=4.3750000e-04     lpdiblc2=6.1875000e-10    pdiblcb=1.0000000e-02
+ drout=0.00                pscbe1=1.8499998e08       lpscbe1=1.4850002e02
+ pscbe2=1.0000000e-06      pvag=0.00                 delta=1.0000000e-02
+ alpha0=0.0                alpha1=7.049416           beta0=21.5673
+ kt1=-0.2967275            lkt1=7.2770190e-09        wkt1=-8.3825920e-09
+ pkt1=8.4720740e-15        kt2=-3.0061465e-02        lkt2=1.0983974e-09
+ wkt2=-1.1603842e-09       pkt2=1.5592368e-15        at=2.0000000e04
+ ute=-1.3914689            lute=1.3138961e-07        wute=9.0155010e-08
+ pute=-7.6784330e-14       ua1=2.0399999e-09         ub1=-2.3428319e-18
+ lub1=2.0287447e-25        wub1=-3.0101820e-26       pub1=1.3061675e-31
+ uc1=-2.2305425e-11        luc1=2.3617550e-17        wuc1=-5.7380370e-17
+ puc1=4.4067530e-23        kt1l=0.00                 prt=0
+ cj=cjn3                   pb=0.7076023              mj=0.3259624
+ cjsw=cjswn3               pbsw=0.7076023            mjsw=0.1513672
+ cjswg=cjswgn3             pbswg=0.7076023           mjswg=0.3513672
+ cgdo=cgon3                cgso=cgon3                tcj=0.0009923959
+ tcjsw=0.0005019466        tcjswg=0.0005019466       tpb=0.001687207
+ tpbsw=0.001687207         tpbswg=0.001687207        js=3.93e-07
+ jsw=1.43e-12              n=1                       xti=3
+ capmod=3                  nqsmod=0                  xpart=1
+ cf=0                      tlev=1                    tlevc=1
+ llc=-0.0165               noimod=2                  noia=1.0e20
+ noib=4.0e04               noic=-4.0e-13             em=3.0e07
+ ef=0.881                  minr=1e-60                imax=0.01
+ imelt=0.01

     7: type=n
+ lmin=5.000e-07-dxln3-dlmis                          lmax=1.200e-06-dxln3-dlmis
+ wmin=1.2000e-06-dxwn3-dwmis                         wmax=1.0000e-05-dxwn3-dwmis
+ tnom=25.0                 version=3.24              tox=toxn3+toxmis
+ toxm=6.8e-09              xj=1.7000001e-07          nch=5.2600000e17
+ lln=-1                    lwn=1.0000000             wln=1.0000000
+ wwn=1.0000000             lint=4.0000000e-08        ll=0.00
+ lw=0.00                   lwl=0.00                  wint=1.4999999e-08
+ wl=0.00                   ww=0.00                   wwl=0.00
+ mobmod=1                  binunit=2                 xl=-0.02e-6+dxln3+dlmis
+ xw=0.0+dxwn3+dwmis        dwg=0.00                  dwb=0.00
+ ldif=9.00e-08             hdif=hdifn3               rsh=rshn3
+ rd=0                      rs=0                      vth0=0.7882218+dvthn3+vthmis
+ lvth0=1.4420463e-08+dlvthn3                         wvth0=-2.7328070e-08+dwvthn3
+ pvth0=1.0125395e-14+dpvthn3                         k1=0.8741527
+ lk1=5.2337620e-08         wk1=-1.5857541e-08        pk1=-1.1638531e-14
+ k2=2.5716120e-02+dk2n3    lk2=-2.7955116e-08+dlk2n3 wk2=8.6687970e-09
+ pk2=6.3712410e-15         k3=0.00                   dvt0=0.00
+ dvt1=0.00                 dvt2=0.00                 dvt0w=0.00
+ dvt1w=0.00                dvt2w=0.00                nlx=0.00
+ w0=0.00                   k3b=0.00                  vsat=9.4142860e04+dvsatn3
+ wvsat=0+dwvsatn3          lvsat=-1.2571429e-03      ua=-5.5216260e-10
+ lua=-1.4134407e-16        wua=1.7172625e-17         pua=-9.7485960e-24
+ ub=2.2626136e-18          lub=1.5997525e-25         wub=-4.1164150e-25
+ pub=-5.6308880e-32        uc=8.8400200e-11          luc=3.0847405e-17
+ wuc=-1.6302085e-17        puc=-1.2113212e-23        rdsw=5.4500000e02
+ prwb=0.00                 prwg=0.00                 wr=1.0000000
+ u0=4.1623130e-02+du0n3    lu0=1.1891720e-09+dlu0n3  wu0=-4.4398320e-09+dwu0n3
+ pu0=4.4061720e-16+dpu0n3  a0=0.5080709              la0=7.6268660e-08
+ wa0=-7.8115730e-08        pa0=4.4293360e-14         keta=3.3942350e-03
+ lketa=-1.5410004e-08      wketa=-3.1994660e-09      pketa=3.4643260e-15
+ a1=0.00                   a2=0.9900000              ags=4.2857140e-02
+ lags=-2.5142862e-08       b0=0.00                   b1=0.00
+ voff=-0.1178869+dvoffn3   lvoff=3.1917740e-09+dlvoffn3
+ wvoff=-2.2461877e-09+dwvoffn3                       pvoff=4.9191660e-15+dpvoffn3
+ nfactor=1.0000000+dnfactorn3                        pnfactor=0+dpnfactorn3
+ wnfactor=0+dwnfactorn3    lnfactor=0+dlnfactorn3    cit=5.2714030e-04
+ lcit=-8.9688470e-12       wcit=-1.8216587e-12       pcit=2.1602446e-18
+ cdsc=0.00                 cdscb=0.00                cdscd=0.00
+ eta0=-1.9886503e-04+deta0n3                         leta0=2.7954594e-10+dleta0n3
+ weta0=-8.3227900e-11+dweta0n3                       peta0=3.3291270e-17+dpeta0n3
+ etab=1.9886503e-04        letab=-2.7954594e-10      wetab=8.3227900e-11
+ petab=-3.3291270e-17      dsub=0.00                 pclm=0.6760895
+ lpclm=7.0287020e-09       wpclm=-7.7639390e-08      ppclm=1.3315938e-13
+ pdiblc1=1.0000000e-06     pdiblc2=1.0042337e-03     lpdiblc2=-4.6571500e-12
+ wpdiblc2=-4.2211370e-11   ppdiblc2=4.6432500e-17    pdiblcb=1.0000000e-02
+ drout=0.00                pscbe1=3.0285712e08       lpscbe1=18.8571820
+ pscbe2=1.0000000e-06      pvag=0.00                 delta=1.0000000e-02
+ alpha0=0.0                alpha1=7.049416           beta0=21.5673
+ kt1=-0.3071715            lkt1=1.8765444e-08        wkt1=1.2860058e-08
+ pkt1=-1.4894836e-14       kt2=-3.2976900e-02        lkt2=4.3053730e-09
+ wkt2=3.7026910e-09        pkt2=-3.7901450e-15       at=2.0000000e04
+ ute=-1.4001315            lute=1.4091844e-07        wute=1.5933820e-07
+ pute=-1.5288584e-13       ua1=2.0399999e-09         ub1=-2.7388682e-18
+ lub1=6.3851440e-25        wub1=6.0409630e-25        pub1=-5.6700110e-31
+ uc1=-7.8913690e-11        luc1=8.5886630e-17        wuc1=3.9538620e-17
+ puc1=-6.2543340e-23       kt1l=0.00                 prt=0
+ cj=cjn3                   pb=0.7076023              mj=0.3259624
+ cjsw=cjswn3               pbsw=0.7076023            mjsw=0.1513672
+ cjswg=cjswgn3             pbswg=0.7076023           mjswg=0.3513672
+ cgdo=cgon3                cgso=cgon3                tcj=0.0009923959
+ tcjsw=0.0005019466        tcjswg=0.0005019466       tpb=0.001687207
+ tpbsw=0.001687207         tpbswg=0.001687207        js=3.93e-07
+ jsw=1.43e-12              n=1                       xti=3
+ capmod=3                  nqsmod=0                  xpart=1
+ cf=0                      tlev=1                    tlevc=1
+ llc=-0.0165               noimod=2                  noia=1.0e20
+ noib=4.0e04               noic=-4.0e-13             em=3.0e07
+ ef=0.881                  minr=1e-60                imax=0.01
+ imelt=0.01

     8: type=n
+ lmin=3.5e-007             lmax=5.000e-07-dxln3-dlmis
+ wmin=1.2000e-06-dxwn3-dwmis                         wmax=1.0000e-05-dxwn3-dwmis
+ tnom=25.0                 version=3.24              tox=toxn3+toxmis
+ toxm=6.8e-09              xj=1.7000001e-07          nch=5.2600000e17
+ lln=-1                    lwn=1.0000000             wln=1.0000000
+ wwn=1.0000000             lint=4.0000000e-08        ll=0.00
+ lw=0.00                   lwl=0.00                  wint=1.4999999e-08
+ wl=0.00                   ww=0.00                   wwl=0.00
+ mobmod=1                  binunit=2                 xl=-0.02e-6+dxln3+dlmis
+ xw=0.0+dxwn3+dwmis        dwg=0.00                  dwb=0.00
+ ldif=9.00e-08             hdif=hdifn3               rsh=rshn3
+ rd=0                      rs=0                      vth0=0.8659324+dvthn3+vthmis
+ lvth0=-1.6663769e-08+dlvthn3                        wvth0=-2.9767808e-09+dwvthn3
+ pvth0=3.8488080e-16+dpvthn3                         k1=0.7465155
+ lk1=1.0339250e-07         wk1=-8.4537670e-08        pk1=1.5833523e-14
+ k2=0.1900880+dk2n3        lk2=-9.3703870e-08+dlk2n3 wk2=4.6535320e-09
+ pk2=7.9773500e-15         k3=0.00                   dvt0=0.00
+ dvt1=0.00                 dvt2=0.00                 dvt0w=0.00
+ dvt1w=0.00                dvt2w=0.00                nlx=0.00
+ w0=0.00                   k3b=0.00                  vsat=9.3130330e04+dvsatn3
+ lvsat=-8.5213050e-04      wvsat=-4.6598160e-03+dwvsatn3
+ pvsat=1.8639263e-09       ua=-6.7444880e-10         lua=-9.2429640e-17
+ wua=-9.2701740e-16        pua=3.6792740e-22         ub=2.1189834e-18
+ lub=2.1742727e-25         wub=5.1692720e-25         pub=-4.2773630e-31
+ uc=2.6250338e-10          luc=-3.8793870e-17        wuc=-1.1458971e-16
+ puc=2.7201846e-23         rdsw=5.4500000e02         prwb=0.00
+ prwg=0.00                 wr=1.0000000              u0=4.3624590e-02+du0n3
+ lu0=3.8858720e-10+dlu0n3  wu0=-9.7397600e-09+dwu0n3 pu0=2.5605882e-15+dpu0n3
+ a0=0.8771189              la0=-7.1350570e-08        wa0=1.2410786e-07
+ pa0=-3.6596080e-14        keta=-5.3992410e-02       lketa=7.5446550e-09
+ wketa=-4.2032270e-08      pketa=1.8997448e-14       a1=0.00
+ a2=0.9900000              ags=-2.0000029e-02        b0=0.00
+ b1=0.00                   voff=-0.1004960+dvoffn3   lvoff=-3.7645670e-09+dlvoffn3
+ wvoff=-4.5400990e-09+dwvoffn3                       pvoff=5.8367300e-15+dpvoffn3
+ nfactor=1.0000000+dnfactorn3                        pnfactor=0+dpnfactorn3
+ wnfactor=0+dwnfactorn3    lnfactor=0+dlnfactorn3    cit=4.8816460e-04
+ lcit=6.6214410e-12        wcit=3.0312121e-11        pcit=-1.0693267e-17
+ cdsc=0.00                 cdscb=0.00                cdscd=0.00
+ eta0=-1.1666667e-03+deta0n3                         peta0=0+dpeta0n3
+ weta0=0+dweta0n3          leta0=6.6666660e-10+dleta0n3
+ etab=3.7764110e-03        letab=-1.7105642e-09      wetab=-1.1034047e-09
+ petab=4.4136180e-16       dsub=0.00                 pclm=-0.2024819
+ lpclm=3.5845730e-07       wpclm=5.9620970e-07       ppclm=-1.3638029e-13
+ pdiblc1=1.0000000e-06     pdiblc2=-1.1344876e-02    lpdiblc2=4.9349870e-09
+ wpdiblc2=6.8173790e-09    ppdiblc2=-2.6974037e-15   pdiblcb=1.0000000e-02
+ drout=0.00                pscbe1=3.5000020e08       pscbe2=1.0000000e-06
+ pvag=0.00                 delta=1.0000000e-02       alpha0=0.0
+ alpha1=7.049416           beta0=21.5673             kt1=-0.2558013
+ lkt1=-1.7826350e-09       wkt1=-1.3100086e-07       pkt1=4.2649530e-14
+ kt2=-1.8057920e-02        lkt2=-1.6622183e-09       wkt2=1.0027706e-09
+ pkt2=-2.7101770e-15       at=2.0123486e04           lat=-4.9394840e-05
+ wat=-1.2311670e-03        pat=4.9246680e-10         ute=-1.0240370
+ lute=-9.5193410e-09       wute=1.8708050e-07        pute=-1.6398275e-13
+ ua1=2.0380289e-09         lua1=7.8843000e-19        wua1=1.9651618e-17
+ pua1=-7.8606470e-24       ub1=-1.5444776e-18        lub1=1.6075813e-25
+ wub1=-5.8817450e-25       pub1=-9.0092720e-32       uc1=1.0033722e-10
+ luc1=1.4186265e-17        wuc1=-9.6220470e-17       puc1=-8.2396960e-24
+ kt1l=0.00                 prt=0                     cj=cjn3
+ pb=0.7076023              mj=0.3259624              cjsw=cjswn3
+ pbsw=0.7076023            mjsw=0.1513672            cjswg=cjswgn3
+ pbswg=0.7076023           mjswg=0.3513672           cgdo=cgon3
+ cgso=cgon3                tcj=0.0009923959          tcjsw=0.0005019466
+ tcjswg=0.0005019466       tpb=0.001687207           tpbsw=0.001687207
+ tpbswg=0.001687207        js=3.93e-07               jsw=1.43e-12
+ n=1                       xti=3                     capmod=3
+ nqsmod=0                  xpart=1                   cf=0
+ tlev=1                    tlevc=1                   llc=-0.0165
+ noimod=2                  noia=1.0e20               noib=4.0e04
+ noic=-4.0e-13             em=3.0e07                 ef=0.881
+ minr=1e-60                imax=0.01                 imelt=0.01

     9: type=n
+ lmin=1.000e-05-dxln3-dlmis                          lmax=20.001e-006
+ wmin=5.0000e-07-dxwn3-dwmis                         wmax=1.2000e-06-dxwn3-dwmis
+ tnom=25.0                 version=3.24              tox=toxn3+toxmis
+ toxm=6.8e-09              xj=1.7000001e-07          nch=5.2600000e17
+ lln=-1                    lwn=1.0000000             wln=1.0000000
+ wwn=1.0000000             lint=4.0000000e-08        ll=0.00
+ lw=0.00                   lwl=0.00                  wint=1.4999999e-08
+ wl=0.00                   ww=0.00                   wwl=0.00
+ mobmod=1                  binunit=2                 xl=-0.02e-6+dxln3+dlmis
+ xw=0.0+dxwn3+dwmis        dwg=0.00                  dwb=0.00
+ ldif=9.00e-08             hdif=hdifn3               rsh=rshn3
+ rd=0                      rs=0                      vth0=0.7453005+dvthn3+vthmis
+ pvth0=0+dpvthn3           lvth0=0+dlvthn3           wvth0=-5.3112130e-09+dwvthn3
+ k1=0.8604288              wk1=7.1317190e-10         k2=3.3322110e-02+dk2n3
+ lk2=0+dlk2n3              wk2=7.9219850e-12         k3=0.00
+ dvt0=0.00                 dvt1=0.00                 dvt2=0.00
+ dvt0w=0.00                dvt1w=0.00                dvt2w=0.00
+ nlx=0.00                  w0=0.00                   k3b=0.00
+ vsat=1.0000000e05+dvsatn3 wvsat=0+dwvsatn3          ua=-6.8333380e-10
+ wua=2.0756087e-17         ub=2.1833304e-18          wub=-1.2117484e-25
+ uc=9.6601420e-11          wuc=-1.0976857e-17        rdsw=5.4500000e02
+ prwb=0.00                 prwg=0.00                 wr=1.0000000
+ u0=3.7005090e-02+du0n3    pu0=0+dpu0n3              lu0=0+dlu0n3
+ wu0=1.2482622e-09+dwu0n3  a0=0.6158070              wa0=1.4977592e-08
+ keta=1.0741917e-02        wketa=-6.9461940e-10      a1=0.00
+ a2=0.9900000              ags=2.0000000e-02         b0=0.00
+ b1=0.00                   voff=-0.1248287+dvoffn3   pvoff=0+dpvoffn3
+ lvoff=0+dlvoffn3          wvoff=-9.6051810e-10+dwvoffn3
+ nfactor=1.0000000+dnfactorn3                        pnfactor=0+dpnfactorn3
+ wnfactor=0+dwnfactorn3    lnfactor=0+dlnfactorn3    cit=1.9465643e-04
+ wcit=1.4539148e-10        cdsc=0.00                 cdscb=0.00
+ cdscd=0.00                eta0=1.0000000e-05+deta0n3
+ peta0=0+dpeta0n3          weta0=0+dweta0n3          leta0=0+dleta0n3
+ etab=-1.0000000e-05       dsub=0.00                 pclm=0.5000000
+ pdiblc1=1.0000000e-06     pdiblc2=5.0000000e-04     pdiblcb=1.0000000e-02
+ drout=0.00                pscbe1=2.0000000e08       pscbe2=1.0000000e-06
+ pvag=0.00                 delta=1.0000000e-02       alpha0=0.0
+ alpha1=7.049416           beta0=21.5673             kt1=-0.3068818
+ wkt1=5.2137960e-09        kt2=-3.1908540e-02        wkt2=1.2880030e-09
+ at=2.0000000e04           ute=-1.3297856            wute=2.5757439e-08
+ ua1=2.0399999e-09         ub1=-2.2946240e-18        wub1=-4.9335480e-26
+ uc1=-4.8472800e-11        wuc1=-1.9522108e-17       kt1l=0.00
+ prt=0                     cj=cjn3                   pb=0.7076023
+ mj=0.3259624              cjsw=cjswn3               pbsw=0.7076023
+ mjsw=0.1513672            cjswg=cjswgn3             pbswg=0.7076023
+ mjswg=0.3513672           cgdo=cgon3                cgso=cgon3
+ tcj=0.0009923959          tcjsw=0.0005019466        tcjswg=0.0005019466
+ tpb=0.001687207           tpbsw=0.001687207         tpbswg=0.001687207
+ js=3.93e-07               jsw=1.43e-12              n=1
+ xti=3                     capmod=3                  nqsmod=0
+ xpart=1                   cf=0                      tlev=1
+ tlevc=1                   llc=-0.0165               noimod=2
+ noia=1.0e20               noib=4.0e04               noic=-4.0e-13
+ em=3.0e07                 ef=0.881                  minr=1e-60
+ imax=0.01                 imelt=0.01

     10: type=n
+ lmin=1.200e-06-dxln3-dlmis                          lmax=1.000e-05-dxln3-dlmis
+ wmin=5.0000e-07-dxwn3-dwmis                         wmax=1.2000e-06-dxwn3-dwmis
+ tnom=25.0                 version=3.24              tox=toxn3+toxmis
+ toxm=6.8e-09              xj=1.7000001e-07          nch=5.2600000e17
+ lln=-1                    lwn=1.0000000             wln=1.0000000
+ wwn=1.0000000             lint=4.0000000e-08        ll=0.00
+ lw=0.00                   lwl=0.00                  wint=1.4999999e-08
+ wl=0.00                   ww=0.00                   wwl=0.00
+ mobmod=1                  binunit=2                 xl=-0.02e-6+dxln3+dlmis
+ xw=0.0+dxwn3+dwmis        dwg=0.00                  dwb=0.00
+ ldif=9.00e-08             hdif=hdifn3               rsh=rshn3
+ rd=0                      rs=0                      vth0=0.7392390+dvthn3+vthmis
+ lvth0=6.0008470e-08+dlvthn3                         wvth0=-4.8123240e-09+dwvthn3
+ pvth0=-4.9390020e-15+dpvthn3                        k1=0.8554150
+ lk1=4.9636120e-08         wk1=1.0075173e-09         pk1=-2.9140208e-15
+ k2=3.5897850e-02+dk2n3    lk2=-2.5499832e-08+dlk2n3 wk2=1.6827269e-11
+ pk2=-8.8160490e-17        k3=0.00                   dvt0=0.00
+ dvt1=0.00                 dvt2=0.00                 dvt0w=0.00
+ dvt1w=0.00                dvt2w=0.00                nlx=0.00
+ w0=0.00                   k3b=0.00                  vsat=1.0087500e05+dvsatn3
+ wvsat=0+dwvsatn3          lvsat=-8.6625000e-03      ua=-6.8346730e-10
+ lua=1.3221220e-18         wua=2.2076628e-17         pua=-1.3073367e-23
+ ub=2.1908280e-18          lub=-7.4224610e-26        wub=-1.2010437e-25
+ pub=-1.0597751e-32        uc=9.5323490e-11          luc=1.2651537e-17
+ wuc=-1.0341395e-17        puc=-6.2910760e-24        rdsw=5.4500000e02
+ prwb=0.00                 prwg=0.00                 wr=1.0000000
+ u0=3.6837630e-02+du0n3    lu0=1.6578280e-09+dlu0n3  wu0=1.2716347e-09+dwu0n3
+ pu0=-2.3138870e-16+dpu0n3 a0=0.6236824              la0=-7.7966580e-08
+ wa0=1.7982831e-08         pa0=-2.9751866e-14        keta=1.3718577e-02
+ lketa=-2.9468925e-08      wketa=-1.1344492e-09      pketa=4.3543190e-15
+ a1=0.00                   a2=0.9900000              ags=2.0000000e-02
+ b0=0.00                   b1=0.00                   voff=-0.1265495+dvoffn3
+ lvoff=1.7036285e-08+dlvoffn3                        wvoff=-7.8502870e-10+dwvoffn3
+ pvoff=-1.7373450e-15+dpvoffn3                       nfactor=1.0000000+dnfactorn3
+ pnfactor=0+dpnfactorn3    wnfactor=0+dwnfactorn3    lnfactor=0+dlnfactorn3
+ cit=1.5283188e-04         lcit=4.1406270e-10        wcit=1.6504902e-10
+ pcit=-1.9460947e-16       cdsc=0.00                 cdscb=0.00
+ cdscd=0.00                eta0=1.0000000e-05+deta0n3
+ peta0=0+dpeta0n3          weta0=0+dweta0n3          leta0=0+dleta0n3
+ etab=-1.0000000e-05       dsub=0.00                 pclm=0.4768089
+ lpclm=2.2959227e-07       wpclm=-4.9807780e-09      ppclm=4.9309700e-14
+ pdiblc1=1.0000000e-06     pdiblc2=4.3750000e-04     lpdiblc2=6.1875000e-10
+ pdiblcb=1.0000000e-02     drout=0.00                pscbe1=1.8500000e08
+ lpscbe1=1.4850000e02      pscbe2=1.0000000e-06      pvag=0.00
+ delta=1.0000000e-02       alpha0=0.0                alpha1=7.049416
+ beta0=21.5673             kt1=-0.3090271            lkt1=2.1238611e-08
+ wkt1=6.0080370e-09        pkt1=-7.8629890e-15       kt2=-3.2233010e-02
+ lkt2=3.2122820e-09        wkt2=1.3803272e-09        pkt2=-9.1400860e-16
+ at=2.0000000e04           ute=-1.3385403            lute=8.6671380e-08
+ wute=2.8228550e-08        pute=-2.4463984e-14       ua1=2.0399999e-09
+ ub1=-2.3244689e-18        lub1=2.9546524e-25        wub1=-5.1586550e-26
+ pub1=2.2285513e-32        uc1=-5.3462490e-11        luc1=4.9397990e-17
+ wuc1=-2.0926594e-17       puc1=1.3904406e-23        kt1l=0.00
+ prt=0                     cj=cjn3                   pb=0.7076023
+ mj=0.3259624              cjsw=cjswn3               pbsw=0.7076023
+ mjsw=0.1513672            cjswg=cjswgn3             pbswg=0.7076023
+ mjswg=0.3513672           cgdo=cgon3                cgso=cgon3
+ tcj=0.0009923959          tcjsw=0.0005019466        tcjswg=0.0005019466
+ tpb=0.001687207           tpbsw=0.001687207         tpbswg=0.001687207
+ js=3.93e-07               jsw=1.43e-12              n=1
+ xti=3                     capmod=3                  nqsmod=0
+ xpart=1                   cf=0                      tlev=1
+ tlevc=1                   llc=-0.0165               noimod=2
+ noia=1.0e20               noib=4.0e04               noic=-4.0e-13
+ em=3.0e07                 ef=0.881                  minr=1e-60
+ imax=0.01                 imelt=0.01

     11: type=n
+ lmin=5.000e-07-dxln3-dlmis                          lmax=1.200e-06-dxln3-dlmis
+ wmin=5.0000e-07-dxwn3-dwmis                         wmax=1.2000e-06-dxwn3-dwmis
+ tnom=25.0                 version=3.24              tox=toxn3+toxmis
+ toxm=6.8e-09              xj=1.7000001e-07          nch=5.2600000e17
+ lln=-1                    lwn=1.0000000             wln=1.0000000
+ wwn=1.0000000             lint=4.0000000e-08        ll=0.00
+ lw=0.00                   lwl=0.00                  wint=1.4999999e-08
+ wl=0.00                   ww=0.00                   wwl=0.00
+ mobmod=1                  binunit=2                 xl=-0.02e-6+dxln3+dlmis
+ xw=0.0+dxwn3+dwmis        dwg=0.00                  dwb=0.00
+ ldif=9.00e-08             hdif=hdifn3               rsh=rshn3
+ rd=0                      rs=0                      vth0=0.7679389+dvthn3+vthmis
+ lvth0=2.8438597e-08+dlvthn3                         wvth0=-3.5970320e-09+dwvthn3
+ pvth0=-6.2758240e-15+dpvthn3                        k1=0.8724138
+ lk1=3.0937503e-08         wk1=-1.3823059e-08        pk1=1.3399614e-14
+ k2=2.7055200e-02+dk2n3    lk2=-1.5772912e-08+dlk2n3 wk2=7.1020800e-09
+ pk2=-7.8819390e-15        k3=0.00                   dvt0=0.00
+ dvt1=0.00                 dvt2=0.00                 dvt0w=0.00
+ dvt1w=0.00                dvt2w=0.00                nlx=0.00
+ w0=0.00                   k3b=0.00                  vsat=9.4142860e04+dvsatn3
+ wvsat=0+dwvsatn3          lvsat=-1.2571429e-03      ua=-5.2107010e-10
+ lua=-1.7731486e-16        wua=-1.9205736e-17        pua=3.2337230e-23
+ ub=1.9324246e-18          lub=2.1001913e-25         wub=-2.5320272e-26
+ pub=-1.1486027e-31        uc=7.7848640e-11          luc=3.1873880e-17
+ wuc=-3.9567560e-18        puc=-1.3314180e-23        rdsw=5.4500000e02
+ prwb=0.00                 prwg=0.00                 wr=1.0000000
+ u0=3.6962610e-02+du0n3    lu0=1.5203439e-09+dlu0n3  wu0=1.0129666e-09+dwu0n3
+ pu0=5.3146080e-17+dpu0n3  a0=0.4526256              la0=1.1019587e-07
+ wa0=-1.3244798e-08        pa0=4.5985210e-15         keta=1.3228342e-03
+ lketa=-1.5833610e-08      wketa=-7.7593030e-10      pketa=3.9599480e-15
+ a1=0.00                   a2=0.9900000              ags=4.2857150e-02
+ lags=-2.5142864e-08       b0=0.00                   b1=0.00
+ voff=-0.1177271+dvoffn3   lvoff=7.3315800e-09+dlvoffn3
+ wvoff=-2.4331537e-09+dwvoffn3                       pvoff=7.5592520e-17+dpvoffn3
+ nfactor=1.0000000+dnfactorn3                        pnfactor=0+dpnfactorn3
+ wnfactor=0+dwnfactorn3    lnfactor=0+dlnfactorn3    cit=5.4556720e-04
+ lcit=-1.7946093e-11       wcit=-2.3381097e-11       pcit=1.2663624e-17
+ cdsc=0.00                 cdscb=0.00                cdscd=0.00
+ eta0=-2.6999993e-04+deta0n3                         peta0=0+dpeta0n3
+ weta0=0+dweta0n3          leta0=3.0799999e-10+dleta0n3
+ etab=2.6999993e-04        letab=-3.0799999e-10      dsub=0.00
+ pclm=0.6877513            lpclm=-2.4444284e-09      wpclm=-9.1283720e-08
+ ppclm=1.4424296e-13       pdiblc1=1.0000000e-06     pdiblc2=1.3304478e-03
+ lpdiblc2=-3.6349270e-10   wpdiblc2=-4.2388190e-10   ppdiblc2=4.6627010e-16
+ pdiblcb=1.0000000e-02     drout=0.00                pscbe1=3.0285712e08
+ lpscbe1=18.8571820        pscbe2=1.0000000e-06      pvag=0.00
+ delta=1.0000000e-02       alpha0=0.0                alpha1=7.049416
+ beta0=21.5673             kt1=-0.2803507            lkt1=-1.0305442e-08
+ wkt1=-1.8520229e-08       pkt1=1.9118106e-14        kt2=-2.7456122e-02
+ lkt2=-2.0422997e-09       wkt2=-2.7566189e-09       pkt2=3.6366320e-15
+ at=2.0000000e04           ute=-1.2687004            lute=9.8474450e-09
+ wute=5.5637800e-09        pute=4.6726310e-16        ua1=2.0399999e-09
+ ub1=-2.1894782e-18        lub1=1.4697553e-25        wub1=-3.8690170e-26
+ pub1=8.0994940e-33        uc1=-3.5313570e-11        luc1=2.9434180e-17
+ wuc1=-1.1473530e-17       puc1=3.5060390e-24        kt1l=0.00
+ prt=0                     cj=cjn3                   pb=0.7076023
+ mj=0.3259624              cjsw=cjswn3               pbsw=0.7076023
+ mjsw=0.1513672            cjswg=cjswgn3             pbswg=0.7076023
+ mjswg=0.3513672           cgdo=cgon3                cgso=cgon3
+ tcj=0.0009923959          tcjsw=0.0005019466        tcjswg=0.0005019466
+ tpb=0.001687207           tpbsw=0.001687207         tpbswg=0.001687207
+ js=3.93e-07               jsw=1.43e-12              n=1
+ xti=3                     capmod=3                  nqsmod=0
+ xpart=1                   cf=0                      tlev=1
+ tlevc=1                   llc=-0.0165               noimod=2
+ noia=1.0e20               noib=4.0e04               noic=-4.0e-13
+ em=3.0e07                 ef=0.881                  minr=1e-60
+ imax=0.01                 imelt=0.01

     12: type=n
+ lmin=3.5e-007             lmax=5.000e-07-dxln3-dlmis
+ wmin=5.0000e-07-dxwn3-dwmis                         wmax=1.2000e-06-dxwn3-dwmis
+ tnom=25.0                 version=3.24              tox=toxn3+toxmis
+ toxm=6.8e-09              xj=1.7000001e-07          nch=5.2600000e17
+ lln=-1                    lwn=1.0000000             wln=1.0000000
+ wwn=1.0000000             lint=4.0000000e-08        ll=0.00
+ lw=0.00                   lwl=0.00                  wint=1.4999999e-08
+ wl=0.00                   ww=0.00                   wwl=0.00
+ mobmod=1                  binunit=2                 xl=-0.02e-6+dxln3+dlmis
+ xw=0.0+dxwn3+dwmis        dwg=0.00                  dwb=0.00
+ ldif=9.00e-08             hdif=hdifn3               rsh=rshn3
+ rd=0                      rs=0                      vth0=0.9005772+dvthn3+vthmis
+ lvth0=-2.4616741e-08+dlvthn3                        wvth0=-4.3511230e-08+dwvthn3
+ pvth0=9.6898540e-15+dpvthn3                         k1=0.6045249
+ lk1=1.3809307e-07         wk1=8.1591280e-08         pk1=-2.4766122e-14
+ k2=0.2179352+dk2n3        lk2=-9.2124900e-08+dlk2n3 wk2=-2.7927635e-08
+ pk2=6.1299460e-15         k3=0.00                   dvt0=0.00
+ dvt1=0.00                 dvt2=0.00                 dvt0w=0.00
+ dvt1w=0.00                dvt2w=0.00                nlx=0.00
+ w0=0.00                   k3b=0.00                  vsat=9.2204430e04+dvsatn3
+ lvsat=-4.8177310e-04      wvsat=-3.5765190e-03+dwvsatn3
+ pvsat=1.4306075e-09       ua=-1.5704804e-09         lua=2.4244926e-16
+ wua=1.2133967e-16         pua=-2.3880921e-23        ub=2.4269640e-18
+ lub=1.2203315e-26         wub=1.5658978e-25         pub=-1.8762427e-31
+ uc=1.6513216e-10          luc=-3.0395374e-18        wuc=-6.6537900e-19
+ puc=-1.4630729e-23        rdsw=5.4500000e02         prwb=0.00
+ prwg=0.00                 wr=1.0000000              u0=3.7385670e-02+du0n3
+ lu0=1.3511215e-09+dlu0n3  wu0=-2.4402242e-09+dwu0n3 pu0=1.4344223e-15+dpu0n3
+ a0=0.8126235              la0=-3.3803300e-08        wa0=1.9956742e-07
+ pa0=-8.0526360e-14        keta=-0.1224256           lketa=3.3665760e-08
+ wketa=3.8034560e-08       pketa=-1.1564247e-14      a1=0.00
+ a2=0.9900000              ags=-1.6226115e-02        lags=-1.5095589e-09
+ wags=-4.4154800e-09       pags=1.7661922e-15        b0=0.00
+ b1=0.00                   voff=-9.9843290e-02+dvoffn3
+ lvoff=1.7806077e-10+dlvoffn3                        wvoff=-5.3038090e-09+dwvoffn3
+ pvoff=1.2238547e-15+dpvoffn3                        nfactor=1.0000000+dnfactorn3
+ pnfactor=0+dpnfactorn3    wnfactor=0+dwnfactorn3    lnfactor=0+dlnfactorn3
+ cit=4.9520520e-04         lcit=2.1987145e-12        wcit=2.2074649e-11
+ pcit=-5.5186740e-18       cdsc=0.00                 cdscb=0.00
+ cdscd=0.00                eta0=-1.1666662e-03+deta0n3
+ peta0=0+dpeta0n3          weta0=0+dweta0n3          leta0=6.6666650e-10+dleta0n3
+ etab=2.8333291e-03        letab=-1.3333316e-09      dsub=0.00
+ pclm=-4.2756410e-02       lpclm=2.8975865e-07       wpclm=4.0933080e-07
+ ppclm=-5.6002840e-14      pdiblc1=1.0000000e-06     pdiblc2=-7.2087520e-03
+ lpdiblc2=3.0521874e-09    wpdiblc2=1.9781137e-09    ppdiblc2=-4.9452820e-16
+ pdiblcb=1.0000000e-02     drout=0.00                pscbe1=3.5000020e08
+ pscbe2=1.0000000e-06      pvag=0.00                 delta=1.0000000e-02
+ alpha0=0.0                alpha1=7.049416           beta0=21.5673
+ kt1=-0.4885682            lkt1=7.2981510e-08        wkt1=1.4133636e-07
+ pkt1=-4.4824520e-14       kt2=-2.8753173e-02        lkt2=-1.5234798e-09
+ wkt2=1.3516213e-08        pkt2=-2.8725001e-15       at=3.0581551e04
+ lat=-4.2326190e-03        wat=-1.3467096e-02        pat=5.3868380e-09
+ ute=-0.7753763            lute=-1.8748216e-07       wute=-1.0385240e-07
+ pute=4.4233730e-14        ua1=1.7494718e-09         lua1=1.1621127e-16
+ wua1=3.5726330e-16        pua1=-1.4290532e-22       ub1=-1.3971897e-18
+ lub1=-1.6993981e-25       wub1=-7.6050110e-25       pub1=2.9682384e-31
+ uc1=6.9721260e-11         luc1=-1.2579750e-17       wuc1=-6.0399780e-17
+ puc1=2.3076537e-23        kt1l=0.00                 prt=0
+ cj=cjn3                   pb=0.7076023              mj=0.3259624
+ cjsw=cjswn3               pbsw=0.7076023            mjsw=0.1513672
+ cjswg=cjswgn3             pbswg=0.7076023           mjswg=0.3513672
+ cgdo=cgon3                cgso=cgon3                tcj=0.0009923959
+ tcjsw=0.0005019466        tcjswg=0.0005019466       tpb=0.001687207
+ tpbsw=0.001687207         tpbswg=0.001687207        js=3.93e-07
+ jsw=1.43e-12              n=1                       xti=3
+ capmod=3                  nqsmod=0                  xpart=1
+ cf=0                      tlev=1                    tlevc=1
+ llc=-0.0165               noimod=2                  noia=1.0e20
+ noib=4.0e04               noic=-4.0e-13             em=3.0e07
+ ef=0.881                  minr=1e-60                imax=0.01
+ imelt=0.01

     13: type=n
+ lmin=1.000e-05-dxln3-dlmis                          lmax=20.001e-006
+ wmin=2.2e-007             wmax=5.0000e-07-dxwn3-dwmis
+ tnom=25.0                 version=3.24              tox=toxn3+toxmis
+ toxm=6.8e-09              xj=1.7000001e-07          nch=5.2600000e17
+ lln=-1                    lwn=1.0000000             wln=1.0000000
+ wwn=1.0000000             lint=4.0000000e-08        ll=0.00
+ lw=0.00                   lwl=0.00                  wint=1.4999999e-08
+ wl=0.00                   ww=0.00                   wwl=0.00
+ mobmod=1                  binunit=2                 xl=-0.02e-6+dxln3+dlmis
+ xw=0.0+dxwn3+dwmis        dwg=0.00                  dwb=0.00
+ ldif=9.00e-08             hdif=hdifn3               rsh=rshn3
+ rd=0                      rs=0                      vth0=0.7828572+dvthn3+vthmis
+ pvth0=0+dpvthn3           lvth0=0+dlvthn3           wvth0=-2.2962862e-08+dwvthn3
+ k1=0.8670291              wk1=-2.3889963e-09        k2=3.3539240e-02+dk2n3
+ lk2=0+dlk2n3              wk2=-9.4124950e-11        k3=0.00
+ dvt0=0.00                 dvt1=0.00                 dvt2=0.00
+ dvt0w=0.00                dvt1w=0.00                dvt2w=0.00
+ nlx=0.00                  w0=0.00                   k3b=0.00
+ vsat=1.0000000e05+dvsatn3 wvsat=0+dwvsatn3          ua=-7.5109630e-10
+ wua=5.2604480e-17         ub=2.0614427e-18          wub=-6.3887530e-26
+ uc=9.9038940e-11          wuc=-1.2122493e-17        rdsw=5.4500000e02
+ prwb=0.00                 prwg=0.00                 wr=1.0000000
+ u0=3.6716620e-02+du0n3    pu0=0+dpu0n3              lu0=0+dlu0n3
+ wu0=1.3838430e-09+dwu0n3  a0=0.6640292              wa0=-7.6868640e-09
+ keta=1.4611328e-02        wketa=-2.5132423e-09      a1=0.00
+ a2=0.9900000              ags=2.0000000e-02         b0=0.00
+ b1=0.00                   voff=-0.1274730+dvoffn3   pvoff=0+dpvoffn3
+ lvoff=0+dlvoffn3          wvoff=2.8231190e-10+dwvoffn3
+ nfactor=1.0000000+dnfactorn3                        pnfactor=0+dpnfactorn3
+ wnfactor=0+dwnfactorn3    lnfactor=0+dlnfactorn3    cit=5.0400000e-04
+ cdsc=0.00                 cdscb=0.00                cdscd=0.00
+ eta0=1.0000000e-05+deta0n3                          peta0=0+dpeta0n3
+ weta0=0+dweta0n3          leta0=0+dleta0n3          etab=-1.0000000e-05
+ dsub=0.00                 pclm=0.5000000            pdiblc1=1.0000000e-06
+ pdiblc2=5.0000000e-04     pdiblcb=1.0000000e-02     drout=0.00
+ pscbe1=2.0000000e08       pscbe2=1.0000000e-06      pvag=0.00
+ delta=1.0000000e-02       alpha0=0.0                alpha1=7.049416
+ beta0=21.5673             kt1=-0.2971856            wkt1=6.5657340e-10
+ kt2=-2.7439827e-02        wkt2=-8.1229250e-10       at=2.0000000e04
+ ute=-1.2430322            wute=-1.5016651e-08       ua1=2.0399999e-09
+ ub1=-2.1566485e-18        wub1=-1.1418396e-25       uc1=-5.2926640e-11
+ wuc1=-1.7428805e-17       kt1l=0.00                 prt=0
+ cj=cjn3                   pb=0.7076023              mj=0.3259624
+ cjsw=cjswn3               pbsw=0.7076023            mjsw=0.1513672
+ cjswg=cjswgn3             pbswg=0.7076023           mjswg=0.3513672
+ cgdo=cgon3                cgso=cgon3                tcj=0.0009923959
+ tcjsw=0.0005019466        tcjswg=0.0005019466       tpb=0.001687207
+ tpbsw=0.001687207         tpbswg=0.001687207        js=3.93e-07
+ jsw=1.43e-12              n=1                       xti=3
+ capmod=3                  nqsmod=0                  xpart=1
+ cf=0                      tlev=1                    tlevc=1
+ llc=-0.0165               noimod=2                  noia=1.0e20
+ noib=4.0e04               noic=-4.0e-13             em=3.0e07
+ ef=0.881                  minr=1e-60                imax=0.01
+ imelt=0.01

     14: type=n
+ lmin=1.200e-06-dxln3-dlmis                          lmax=1.000e-05-dxln3-dlmis
+ wmin=2.2e-007             wmax=5.0000e-07-dxwn3-dwmis
+ tnom=25.0                 version=3.24              tox=toxn3+toxmis
+ toxm=6.8e-09              xj=1.7000001e-07          nch=5.2600000e17
+ lln=-1                    lwn=1.0000000             wln=1.0000000
+ wwn=1.0000000             lint=4.0000000e-08        ll=0.00
+ lw=0.00                   lwl=0.00                  wint=1.4999999e-08
+ wl=0.00                   ww=0.00                   wwl=0.00
+ mobmod=1                  binunit=2                 xl=-0.02e-6+dxln3+dlmis
+ xw=0.0+dxwn3+dwmis        dwg=0.00                  dwb=0.00
+ ldif=9.00e-08             hdif=hdifn3               rsh=rshn3
+ rd=0                      rs=0                      vth0=0.7804866+dvthn3+vthmis
+ lvth0=2.3468242e-08+dlvthn3                         wvth0=-2.4198712e-08+dwvthn3
+ pvth0=1.2234904e-14+dpvthn3                         k1=0.8636016
+ lk1=3.3932720e-08         wk1=-2.8401654e-09        pk1=4.4665790e-15
+ k2=3.5084160e-02+dk2n3    lk2=-1.5294709e-08+dlk2n3 wk2=3.9926540e-10
+ pk2=-4.8845690e-15        k3=0.00                   dvt0=0.00
+ dvt1=0.00                 dvt2=0.00                 dvt0w=0.00
+ dvt1w=0.00                dvt2w=0.00                nlx=0.00
+ w0=0.00                   k3b=0.00                  vsat=1.0087500e05+dvsatn3
+ wvsat=0+dwvsatn3          lvsat=-8.6625000e-03      ua=-7.5848670e-10
+ lua=7.3164600e-17         wua=5.7335730e-17         pua=-4.6839330e-23
+ ub=2.0926081e-18          lub=-3.0854041e-25        wub=-7.3941130e-26
+ pub=9.9530690e-32         uc=1.0056940e-10          luc=-1.5151562e-17
+ wuc=-1.2806976e-17        puc=6.7763810e-24         rdsw=5.4500000e02
+ prwb=0.00                 prwg=0.00                 wr=1.0000000
+ u0=3.7054640e-02+du0n3    lu0=-3.3465050e-09+dlu0n3 wu0=1.1696366e-09+dwu0n3
+ pu0=2.1206480e-15+dpu0n3  a0=0.6665249              la0=-2.4707576e-08
+ wa0=-2.1531732e-09        pa0=-5.4783600e-14        keta=1.5772361e-02
+ lketa=-1.1494187e-08      wketa=-2.0997273e-09      pketa=-4.0938080e-15
+ a1=0.00                   a2=0.9900000              ags=2.0000000e-02
+ b0=0.00                   b1=0.00                   voff=-0.1297337+dvoffn3
+ lvoff=2.2381130e-08+dlvoffn3                        wvoff=7.1154630e-10+dwvoffn3
+ pvoff=-4.2494230e-15+dpvoffn3                       nfactor=1.0000000+dnfactorn3
+ pnfactor=0+dpnfactorn3    wnfactor=0+dwnfactorn3    lnfactor=0+dlnfactorn3
+ cit=5.0400000e-04         cdsc=0.00                 cdscb=0.00
+ cdscd=0.00                eta0=1.0000000e-05+deta0n3
+ peta0=0+dpeta0n3          weta0=0+dweta0n3          leta0=0+dleta0n3
+ etab=-1.0000000e-05       dsub=0.00                 pclm=0.4717489
+ lpclm=2.7968576e-07       wpclm=-2.6026028e-09      ppclm=2.5765768e-14
+ pdiblc1=1.0000000e-06     pdiblc2=4.3750000e-04     lpdiblc2=6.1874990e-10
+ pdiblcb=1.0000000e-02     drout=0.00                pscbe1=1.8500000e08
+ lpscbe1=1.4850000e02      pscbe2=1.0000000e-06      pvag=0.00
+ delta=1.0000000e-02       alpha0=0.0                alpha1=7.049416
+ beta0=21.5673             kt1=-0.2951206            lkt1=-2.0443341e-08
+ wkt1=-5.2802380e-10       pkt1=1.1727529e-14        kt2=-2.7106613e-02
+ lkt2=-3.2988250e-09       wkt2=-1.0290813e-09       pkt2=2.1462119e-15
+ at=2.0000000e04           ute=-1.2394767            lute=-3.5199690e-08
+ wute=-1.8331338e-08       pute=3.2815420e-14        ua1=2.0399999e-09
+ ub1=-2.1723405e-18        lub1=1.5535091e-25        wub1=-1.2308690e-25
+ pub1=8.8139250e-32        uc1=-5.9918290e-11        luc1=6.9217410e-17
+ wuc1=-1.7892370e-17       puc1=4.5892800e-24        kt1l=0.00
+ prt=0                     cj=cjn3                   pb=0.7076023
+ mj=0.3259624              cjsw=cjswn3               pbsw=0.7076023
+ mjsw=0.1513672            cjswg=cjswgn3             pbswg=0.7076023
+ mjswg=0.3513672           cgdo=cgon3                cgso=cgon3
+ tcj=0.0009923959          tcjsw=0.0005019466        tcjswg=0.0005019466
+ tpb=0.001687207           tpbsw=0.001687207         tpbswg=0.001687207
+ js=3.93e-07               jsw=1.43e-12              n=1
+ xti=3                     capmod=3                  nqsmod=0
+ xpart=1                   cf=0                      tlev=1
+ tlevc=1                   llc=-0.0165               noimod=2
+ noia=1.0e20               noib=4.0e04               noic=-4.0e-13
+ em=3.0e07                 ef=0.881                  minr=1e-60
+ imax=0.01                 imelt=0.01

     15: type=n
+ lmin=5.000e-07-dxln3-dlmis                          lmax=1.200e-06-dxln3-dlmis
+ wmin=2.2e-007             wmax=5.0000e-07-dxwn3-dwmis
+ tnom=25.0                 version=3.24              tox=toxn3+toxmis
+ toxm=6.8e-09              xj=1.7000001e-07          nch=5.2600000e17
+ lln=-1                    lwn=1.0000000             wln=1.0000000
+ wwn=1.0000000             lint=4.0000000e-08        ll=0.00
+ lw=0.00                   lwl=0.00                  wint=1.4999999e-08
+ wl=0.00                   ww=0.00                   wwl=0.00
+ mobmod=1                  binunit=2                 xl=-0.02e-6+dxln3+dlmis
+ xw=0.0+dxwn3+dwmis        dwg=0.00                  dwb=0.00
+ ldif=9.00e-08             hdif=hdifn3               rsh=rshn3
+ rd=0                      rs=0                      vth0=0.7807397+dvthn3+vthmis
+ lvth0=2.3189909e-08+dlvthn3                         wvth0=-9.6134030e-09+dwvthn3
+ pvth0=-3.8089400e-15+dpvthn3                        k1=0.7736582
+ lk1=1.3287044e-07         wk1=3.2592050e-08         pk1=-3.4508860e-14
+ k2=6.4881680e-02+dk2n3    lk2=-4.8071990e-08+dlk2n3 wk2=-1.0676364e-08
+ pk2=7.2986250e-15         k3=0.00                   dvt0=0.00
+ dvt1=0.00                 dvt2=0.00                 dvt0w=0.00
+ dvt1w=0.00                dvt2w=0.00                nlx=0.00
+ w0=0.00                   k3b=0.00                  vsat=9.4142860e04+dvsatn3
+ wvsat=0+dwvsatn3          lvsat=-1.2571429e-03      ua=-5.9941190e-10
+ lua=-1.0181772e-16        wua=1.7614915e-17         pua=-3.1464334e-24
+ ub=1.5764261e-18          lub=2.5926002e-25         wub=1.4199901e-25
+ pub=-1.3800350e-31        uc=4.5846500e-11          luc=4.5043640e-17
+ wuc=1.1084252e-17         puc=-1.9503975e-23        rdsw=5.4500000e02
+ prwb=0.00                 prwg=0.00                 wr=1.0000000
+ u0=3.1034408e-02+du0n3    lu0=3.2757530e-09+dlu0n3  wu0=3.7992220e-09+dwu0n3
+ pu0=-7.7189640e-16+dpu0n3 a0=0.4857765              la0=1.7411581e-07
+ wa0=-2.8825673e-08        pa0=-2.5443860e-14        keta=2.5973169e-02
+ lketa=-2.2715076e-08      wketa=-1.2361587e-08      pketa=7.1942380e-15
+ a1=0.00                   a2=0.9900000              ags=4.2857150e-02
+ lags=-2.5142864e-08       b0=0.00                   b1=0.00
+ voff=-0.1085447+dvoffn3   lvoff=-9.2680400e-10+dlvoffn3
+ wvoff=-6.7488680e-09+dwvoffn3                       pvoff=3.9570330e-15+dpvoffn3
+ nfactor=1.0000000+dnfactorn3                        pnfactor=0+dpnfactorn3
+ wnfactor=0+dwnfactorn3    lnfactor=0+dlnfactorn3    cit=5.4827290e-04
+ lcit=-4.8700200e-11       wcit=-2.4652778e-11       pcit=2.7118061e-17
+ cdsc=0.00                 cdscb=0.00                cdscd=0.00
+ eta0=-2.7000002e-04+deta0n3                         peta0=0+dpeta0n3
+ weta0=0+dweta0n3          leta0=3.0800001e-10+dleta0n3
+ etab=2.7000002e-04        letab=-3.0800001e-10      dsub=0.00
+ pclm=0.6242409            lpclm=1.1194462e-07       wpclm=-6.1433820e-08
+ ppclm=9.0480110e-14       pdiblc1=1.0000000e-06     pdiblc2=4.2857150e-04
+ lpdiblc2=6.2857140e-10    pdiblcb=1.0000000e-02     drout=0.00
+ pscbe1=3.0285712e08       lpscbe1=18.8571830        pscbe2=1.0000000e-06
+ pvag=0.00                 delta=1.0000000e-02       alpha0=0.0
+ alpha1=7.049416           beta0=21.5673             kt1=-0.3598902
+ lkt1=5.0803170e-08        wkt1=1.8863313e-08        pkt1=-9.6029440e-15
+ kt2=-3.7711450e-02        lkt2=8.3664990e-09        wkt2=2.0633864e-09
+ pkt2=-1.2555028e-15       at=2.0000000e04           ute=-1.3677146
+ lute=1.0586200e-07        wute=5.2100470e-08        pute=-4.4659580e-14
+ ua1=2.0399999e-09         ub1=-2.1250930e-18        lub1=1.0337858e-25
+ wub1=-6.8951290e-26       pub1=2.8590071e-32        uc1=-3.6162200e-12
+ luc1=7.2851270e-18        wuc1=-2.6371291e-17       puc1=1.3916098e-23
+ kt1l=0.00                 prt=0                     cj=cjn3
+ pb=0.7076023              mj=0.3259624              cjsw=cjswn3
+ pbsw=0.7076023            mjsw=0.1513672            cjswg=cjswgn3
+ pbswg=0.7076023           mjswg=0.3513672           cgdo=cgon3
+ cgso=cgon3                tcj=0.0009923959          tcjsw=0.0005019466
+ tcjswg=0.0005019466       tpb=0.001687207           tpbsw=0.001687207
+ tpbswg=0.001687207        js=3.93e-07               jsw=1.43e-12
+ n=1                       xti=3                     capmod=3
+ nqsmod=0                  xpart=1                   cf=0
+ tlev=1                    tlevc=1                   llc=-0.0165
+ noimod=2                  noia=1.0e20               noib=4.0e04
+ noic=-4.0e-13             em=3.0e07                 ef=0.881
+ minr=1e-60                imax=0.01                 imelt=0.01

     16: type=n
+ lmin=3.5e-007             lmax=5.000e-07-dxln3-dlmis
+ wmin=2.2e-007             wmax=5.0000e-07-dxwn3-dwmis
+ tnom=25.0                 version=3.24              tox=toxn3+toxmis
+ toxm=6.8e-09              xj=1.7000001e-07          nch=5.2600000e17
+ lln=-1                    lwn=1.0000000             wln=1.0000000
+ wwn=1.0000000             lint=4.0000000e-08        ll=0.00
+ lw=0.00                   lwl=0.00                  wint=1.4999999e-08
+ wl=0.00                   ww=0.00                   wwl=0.00
+ mobmod=1                  binunit=2                 xl=-0.02e-6+dxln3+dlmis
+ xw=0.0+dxwn3+dwmis        dwg=0.00                  dwb=0.00
+ ldif=9.00e-08             hdif=hdifn3               rsh=rshn3
+ rd=0                      rs=0                      vth0=0.8306194+dvthn3+vthmis
+ lvth0=3.2380310e-09+dlvthn3                         wvth0=-1.0631036e-08+dwvthn3
+ pvth0=-3.4018870e-15+dpvthn3                        k1=1.0625753
+ lk1=1.7303593e-08         wk1=-1.3369242e-07        pk1=3.2004920e-14
+ k2=0.1064665+dk2n3        lk2=-6.4705920e-08+dlk2n3 wk2=2.4462622e-08
+ pk2=-6.7569720e-15        k3=0.00                   dvt0=0.00
+ dvt1=0.00                 dvt2=0.00                 dvt0w=0.00
+ dvt1w=0.00                dvt2w=0.00                nlx=0.00
+ w0=0.00                   k3b=0.00                  vsat=9.3605550e04+dvsatn3
+ lvsat=-1.0422204e-03      wvsat=-4.2350440e-03+dwvsatn3
+ pvsat=1.6940175e-09       ua=6.7111770e-11          lua=-3.6842710e-16
+ wua=-6.4832840e-16        pua=2.6323089e-22         ub=1.2076053e-18
+ lub=4.0678830e-25         wub=7.2968810e-25         pub=-3.7307910e-31
+ uc=1.8743894e-10          luc=-1.1593328e-17        wuc=-1.1149585e-17
+ puc=-1.0610441e-23        rdsw=5.4500000e02         prwb=0.00
+ prwg=0.00                 wr=1.0000000              u0=5.3736130e-02+du0n3
+ lu0=-5.8049360e-09+dlu0n3 wu0=-1.0124940e-08+dwu0n3 pu0=4.7977680e-15+dpu0n3
+ a0=1.0752125              la0=-6.1658620e-08        wa0=7.6150530e-08
+ pa0=-6.7434340e-14        keta=-9.2701760e-02       lketa=2.4754891e-08
+ wketa=2.4064352e-08       pketa=-7.3761370e-15      a1=0.00
+ a2=0.9900000              ags=1.0422147e-02         lags=-1.2168864e-08
+ wags=-1.6940159e-08       pags=6.7760640e-15        b0=0.00
+ b1=0.00                   voff=-0.1289647+dvoffn3   lvoff=7.2411770e-09+dlvoffn3
+ wvoff=8.3832410e-09+dwvoffn3                        pvoff=-2.0958096e-15+dpvoffn3
+ nfactor=1.0000000+dnfactorn3                        pnfactor=0+dpnfactorn3
+ wnfactor=0+dwnfactorn3    lnfactor=0+dlnfactorn3    cit=2.9739301e-04
+ lcit=5.1651740e-11        wcit=1.1504635e-10        pcit=-2.8761589e-17
+ cdsc=0.00                 cdscb=0.00                cdscd=0.00
+ eta0=-1.1666659e-03+deta0n3                         peta0=0+dpeta0n3
+ weta0=0+dweta0n3          leta0=6.6666640e-10+dleta0n3
+ etab=2.8333315e-03        letab=-1.3333327e-09      dsub=0.00
+ pclm=0.5943905            lpclm=1.2388473e-07       wpclm=1.0987172e-07
+ ppclm=2.1957893e-14       pdiblc1=1.0000000e-06     pdiblc2=-2.9999996e-03
+ lpdiblc2=1.9999999e-09    pdiblcb=1.0000000e-02     drout=0.00
+ pscbe1=3.5000020e08       pscbe2=1.0000000e-06      pvag=0.00
+ delta=1.0000000e-02       alpha0=0.0                alpha1=7.049416
+ beta0=21.5673             kt1=-0.1415831            lkt1=-3.6519680e-08
+ wkt1=-2.1746652e-08       pkt1=6.6410420e-15        kt2=3.7919310e-03
+ lkt2=-8.2348550e-09       wkt2=-1.7799852e-09       pkt2=2.8184582e-16
+ at=1.0938882e04           lat=3.6244480e-03         wat=-4.2350400e-03
+ pat=1.6940163e-09         ute=-0.9606272            lute=-5.6972970e-08
+ wute=-1.6784552e-08       pute=-1.7105571e-14       ua1=1.2040989e-09
+ lua1=3.3436030e-16        wua1=6.1358830e-16        pua1=-2.4543530e-22
+ ub1=-5.2839440e-19        lub1=-5.3530060e-25       wub1=-1.1688345e-24
+ pub1=4.6854330e-31        uc1=6.8918580e-11         luc1=-2.1728796e-17
+ wuc1=-6.0022500e-17       puc1=2.7376582e-23        kt1l=0.00
+ prt=0                     cj=cjn3                   pb=0.7076023
+ mj=0.3259624              cjsw=cjswn3               pbsw=0.7076023
+ mjsw=0.1513672            cjswg=cjswgn3             pbswg=0.7076023
+ mjswg=0.3513672           cgdo=cgon3                cgso=cgon3
+ tcj=0.0009923959          tcjsw=0.0005019466        tcjswg=0.0005019466
+ tpb=0.001687207           tpbsw=0.001687207         tpbswg=0.001687207
+ js=3.93e-07               jsw=1.43e-12              n=1
+ xti=3                     capmod=3                  nqsmod=0
+ xpart=1                   cf=0                      tlev=1
+ tlevc=1                   llc=-0.0165               noimod=2
+ noia=1.0e20               noib=4.0e04               noic=-4.0e-13
+ em=3.0e07                 ef=0.881                  minr=1e-60
+ imax=0.01                 imelt=0.01

     }
ends nch3_mis

subckt pch3_mis ( d g s b )
parameters l=35.e-08 w=1.5e-6 multi=1 ad=2*hdifp3*w as=2*hdifp3*w pd=2*(2*hdifp3+w) ps=2*(2*hdifp3+w) nrd=hdifp3/w nrs=hdifp3/w
+ lef=l - 20e-9 wef=w geo_fac=1 / sqrt(multi
+ * lef * wef * 1e12) vthmis=4.525e-3 * geo_fac * vthpmis3 dlmis=2.47e-3 * geo_fac
+ * lef * dlpmis3 dwmis=2.01e-3 * geo_fac * wef * dwpmis3 toxmis=5.43e-4 * geo_fac
+ * toxp3 * toxpmis3
m0 ( d g s b ) pch3mis w=w l=l ad=ad as=as pd=pd ps=ps nrd=nrd nrs=nrs m=multi

model pch3mis bsim3v3  {
     1: type=p
+ lmin=1.000e-05-dxlp3-dlmis                          lmax=20.001e-006
+ wmin=1.0000e-05-dxwp3-dwmis                         wmax=900.001e-6
+ tnom=25.0                 version=3.24              tox=toxp3+toxmis
+ toxm=6.77e-09             xj=1.7000001e-07          nch=4.9500000e17
+ lln=-1                    lwn=1.0000000             wln=1.0000000
+ wwn=1.0000000             lint=3.5000000e-08        ll=0.00
+ lw=0.00                   lwl=0.00                  wint=2.0000000e-08
+ wl=0.00                   ww=0.00                   wwl=0.00
+ mobmod=1                  binunit=2                 xl=-0.02e-6+dxlp3+dlmis
+ xw=0.0+dxwp3+dwmis        dwg=0.00                  dwb=0.00
+ ldif=9.00e-08             hdif=hdifp3               rsh=rshp3
+ rd=0                      rs=0                      vth0=-0.6977456+dvthp3+vthmis
+ pvth0=0+dpvthp3           wvth0=0+dwvthp3           lvth0=0+dlvthp3
+ k1=0.8513944              k2=7.3231060e-02+dk2p3    lk2=0+dlk2p3
+ k3=0.00                   dvt0=0.00                 dvt1=0.00
+ dvt2=0.00                 dvt0w=0.00                dvt1w=0.00
+ dvt2w=0.00                nlx=0.00                  w0=0.00
+ k3b=0.00                  vsat=1.5000002e05+dvsatp3 wvsat=0+dwvsatp3
+ ua=1.6792380e-09          ub=2.7609050e-19          uc=-1.0631042e-10
+ rdsw=9.0000000e02         prwb=0.00                 prwg=0.00
+ wr=1.0000000              u0=1.3079101e-02+du0p3    pu0=0+dpu0p3
+ wu0=0+dwu0p3              lu0=0+dlu0p3              a0=0.9726100
+ keta=1.9578772e-02        a1=0.00                   a2=0.9900000
+ ags=2.0000000e-02         b0=0.00                   b1=0.00
+ voff=-0.1119244+dvoffp3   pvoff=0+dpvoffp3          wvoff=0+dwvoffp3
+ lvoff=0+dlvoffp3          nfactor=1.0000000+dnfactorp3
+ pnfactor=0+dpnfactorp3    wnfactor=0+dwnfactorp3    lnfactor=0+dlnfactorp3
+ cit=4.5372260e-04         cdsc=0.00                 cdscb=0.00
+ cdscd=0.00                eta0=1.0000000e-05+deta0p3
+ peta0=0+dpeta0p3          weta0=0+dweta0p3          leta0=0+dleta0p3
+ etab=-1.0000000e-05       dsub=0.00                 pclm=0.5000001
+ pdiblc1=1.0000000e-06     pdiblc2=1.0000000e-05     pdiblcb=1.0000000e-02
+ drout=0.00                pscbe1=2.0000003e08       pscbe2=5.0000000e-07
+ pvag=0.00                 delta=1.0000000e-02       alpha0=0.00
+ alpha1=0.143217238        beta0=16.10832            kt1=-0.2913002
+ kt2=-2.5890822e-02        at=-5.0000000e04          ute=-0.7959498
+ ua1=2.0310000e-09         ub1=-2.6231965e-18        uc1=9.4352360e-12
+ kt1l=0.00                 prt=0                     cj=cjp3
+ pb=0.8049122              mj=0.3954951              cjsw=cjswp3
+ pbsw=0.8049122            mjsw=0.2573111            cjswg=cjswgp3
+ pbswg=0.8049122           mjswg=0.2573111           cgdo=cgop3
+ cgso=cgop3                tcj=0.0009940197          tcjsw=0.0006908749
+ tcjswg=0.0006908749       tpb=0.001625007           tpbsw=0.001625007
+ tpbswg=0.001625007        js=1.900e-07              jsw=1.00e-12
+ n=1                       xti=3                     capmod=3
+ nqsmod=0                  xpart=1                   cf=0
+ tlev=1                    tlevc=1                   llc=-0.0165
+ noimod=2                  noia=2.0e19               noib=8.0e03
+ noic=5.4e-12              em=3.0e07                 ef=1.094
+ minr=1e-60                imax=0.01                 imelt=0.01

     2: type=p
+ lmin=1.200e-06-dxlp3-dlmis                          lmax=1.000e-05-dxlp3-dlmis
+ wmin=1.0000e-05-dxwp3-dwmis                         wmax=900.001e-6
+ tnom=25.0                 version=3.24              tox=toxp3+toxmis
+ toxm=6.77e-09             xj=1.7000001e-07          nch=4.9500000e17
+ lln=-1                    lwn=1.0000000             wln=1.0000000
+ wwn=1.0000000             lint=3.5000000e-08        ll=0.00
+ lw=0.00                   lwl=0.00                  wint=2.0000000e-08
+ wl=0.00                   ww=0.00                   wwl=0.00
+ mobmod=1                  binunit=2                 xl=-0.02e-6+dxlp3+dlmis
+ xw=0.0+dxwp3+dwmis        dwg=0.00                  dwb=0.00
+ ldif=9.00e-08             hdif=hdifp3               rsh=rshp3
+ rd=0                      rs=0                      vth0=-0.6966490+dvthp3+vthmis
+ pvth0=0+dpvthp3           wvth0=0+dwvthp3           lvth0=-1.0866771e-08+dlvthp3
+ k1=0.8495954              lk1=1.7827986e-08         k2=7.3845220e-02+dk2p3
+ lk2=-6.0863510e-09+dlk2p3 k3=0.00                   dvt0=0.00
+ dvt1=0.00                 dvt2=0.00                 dvt0w=0.00
+ dvt1w=0.00                dvt2w=0.00                nlx=0.00
+ w0=0.00                   k3b=0.00                  vsat=1.5378411e05+dvsatp3
+ wvsat=0+dwvsatp3          lvsat=-3.7500340e-02      ua=1.6902475e-09
+ lua=-1.0910469e-16        ub=2.6840783e-19          lub=7.6135260e-26
+ uc=-1.0827022e-10         luc=1.9421627e-17         rdsw=9.0000000e02
+ prwb=0.00                 prwg=0.00                 wr=1.0000000
+ u0=1.3233015e-02+du0p3    pu0=0+dpu0p3              wu0=0+dwu0p3
+ lu0=-1.5252891e-09+dlu0p3 a0=0.9807407              la0=-8.0575180e-08
+ keta=2.0751586e-02        lketa=-1.1622598e-08      a1=0.00
+ a2=0.9900000              ags=2.0000000e-02         b0=0.00
+ b1=0.00                   voff=-0.1119000+dvoffp3   pvoff=0+dpvoffp3
+ wvoff=0+dwvoffp3          lvoff=-2.4146618e-10+dlvoffp3
+ nfactor=1.0000000+dnfactorp3                        pnfactor=0+dpnfactorp3
+ wnfactor=0+dwnfactorp3    lnfactor=0+dlnfactorp3    cit=4.4763520e-04
+ lcit=6.0325690e-11        cdsc=0.00                 cdscb=0.00
+ cdscd=0.00                eta0=1.0000000e-05+deta0p3
+ peta0=0+dpeta0p3          weta0=0+dweta0p3          leta0=0+dleta0p3
+ etab=-1.0000000e-05       dsub=0.00                 pclm=0.4845105
+ lpclm=1.5350197e-07       pdiblc1=1.0000000e-06     pdiblc2=1.0000000e-05
+ pdiblcb=1.0000000e-02     drout=0.00                pscbe1=1.8738642e08
+ lpscbe1=1.2500109e02      pscbe2=5.0000000e-07      pvag=0.00
+ delta=1.0000000e-02       alpha0=0.00               alpha1=0.143217238
+ beta0=16.10832            kt1=-0.2904292            lkt1=-8.6317250e-09
+ kt2=-2.5863823e-02        lkt2=-2.6755742e-10       at=-5.0000000e04
+ ute=-0.8086896            lute=1.2625190e-07        ua1=2.0310000e-09
+ ub1=-2.6370268e-18        lub1=1.3705860e-25        uc1=7.1907790e-12
+ luc1=2.2242592e-17        kt1l=0.00                 prt=0
+ cj=cjp3                   pb=0.8049122              mj=0.3954951
+ cjsw=cjswp3               pbsw=0.8049122            mjsw=0.2573111
+ cjswg=cjswgp3             pbswg=0.8049122           mjswg=0.2573111
+ cgdo=cgop3                cgso=cgop3                tcj=0.0009940197
+ tcjsw=0.0006908749        tcjswg=0.0006908749       tpb=0.001625007
+ tpbsw=0.001625007         tpbswg=0.001625007        js=1.900e-07
+ jsw=1.00e-12              n=1                       xti=3
+ capmod=3                  nqsmod=0                  xpart=1
+ cf=0                      tlev=1                    tlevc=1
+ llc=-0.0165               noimod=2                  noia=2.0e19
+ noib=8.0e03               noic=5.4e-12              em=3.0e07
+ ef=1.094                  minr=1e-60                imax=0.01
+ imelt=0.01

     3: type=p
+ lmin=5.000e-07-dxlp3-dlmis                          lmax=1.200e-06-dxlp3-dlmis
+ wmin=1.0000e-05-dxwp3-dwmis                         wmax=900.001e-6
+ tnom=25.0                 version=3.24              tox=toxp3+toxmis
+ toxm=6.77e-09             xj=1.7000001e-07          nch=4.9500000e17
+ lln=-1                    lwn=1.0000000             wln=1.0000000
+ wwn=1.0000000             lint=3.5000000e-08        ll=0.00
+ lw=0.00                   lwl=0.00                  wint=2.0000000e-08
+ wl=0.00                   ww=0.00                   wwl=0.00
+ mobmod=1                  binunit=2                 xl=-0.02e-6+dxlp3+dlmis
+ xw=0.0+dxwp3+dwmis        dwg=0.00                  dwb=0.00
+ ldif=9.00e-08             hdif=hdifp3               rsh=rshp3
+ rd=0                      rs=0                      vth0=-0.7066531+dvthp3+vthmis
+ pvth0=0+dpvthp3           wvth0=0+dwvthp3           lvth0=2.3770189e-10+dlvthp3
+ k1=0.8542004              lk1=1.2716471e-08         k2=7.3637170e-02+dk2p3
+ lk2=-5.8554080e-09+dlk2p3 k3=0.00                   dvt0=0.00
+ dvt1=0.00                 dvt2=0.00                 dvt0w=0.00
+ dvt1w=0.00                dvt2w=0.00                nlx=0.00
+ w0=0.00                   k3b=0.00                  vsat=1.2585714e05+dvsatp3
+ wvsat=0+dwvsatp3          lvsat=-6.5014080e-03      ua=2.0603699e-09
+ lua=-5.1994050e-16        ub=1.0048677e-19          lub=2.6252766e-25
+ uc=-1.2948420e-10         luc=4.2969150e-17         rdsw=9.0000000e02
+ prwb=0.00                 prwg=0.00                 wr=1.0000000
+ u0=1.3020334e-02+du0p3    pu0=0+dpu0p3              wu0=0+dwu0p3
+ lu0=-1.2892131e-09+dlu0p3 a0=0.8873466              la0=2.3092309e-08
+ keta=2.0400845e-02        lketa=-1.1233276e-08      a1=0.00
+ a2=0.9900000              ags=2.0000000e-02         b0=0.00
+ b1=0.00                   voff=-0.1168895+dvoffp3   pvoff=0+dpvoffp3
+ wvoff=0+dwvoffp3          lvoff=5.2969330e-09+dlvoffp3
+ nfactor=1.0000000+dnfactorp3                        pnfactor=0+dpnfactorp3
+ wnfactor=0+dwnfactorp3    lnfactor=0+dlnfactorp3    cit=4.9963790e-04
+ lcit=2.6027104e-12        cdsc=0.00                 cdscb=0.00
+ cdscd=0.00                eta0=-4.2714270e-05+deta0p3
+ peta0=0+dpeta0p3          weta0=0+dweta0p3          leta0=5.8512850e-11+dleta0p3
+ etab=4.2714270e-05        letab=-5.8512850e-11      dsub=0.00
+ pclm=0.5865320            lpclm=4.0258040e-08       pdiblc1=1.0000000e-06
+ pdiblc2=-5.6985720e-04    lpdiblc2=6.4364150e-10    pdiblcb=1.0000000e-02
+ drout=0.00                pscbe1=2.7071427e08       lpscbe1=32.5071400
+ pscbe2=5.0000000e-07      pvag=0.00                 delta=1.0000000e-02
+ alpha0=0.00               alpha1=0.143217238        beta0=16.10832
+ kt1=-0.2962146            lkt1=-2.2099222e-09       kt2=-2.4729839e-02
+ lkt2=-1.5262811e-09       at=-5.0000000e04          ute=-0.7447437
+ lute=5.5271930e-08        ua1=2.0310000e-09         ub1=-2.7745749e-18
+ lub1=2.8973695e-25        uc1=2.7087265e-11         luc1=1.5749189e-19
+ kt1l=0.00                 prt=0                     cj=cjp3
+ pb=0.8049122              mj=0.3954951              cjsw=cjswp3
+ pbsw=0.8049122            mjsw=0.2573111            cjswg=cjswgp3
+ pbswg=0.8049122           mjswg=0.2573111           cgdo=cgop3
+ cgso=cgop3                tcj=0.0009940197          tcjsw=0.0006908749
+ tcjswg=0.0006908749       tpb=0.001625007           tpbsw=0.001625007
+ tpbswg=0.001625007        js=1.900e-07              jsw=1.00e-12
+ n=1                       xti=3                     capmod=3
+ nqsmod=0                  xpart=1                   cf=0
+ tlev=1                    tlevc=1                   llc=-0.0165
+ noimod=2                  noia=2.0e19               noib=8.0e03
+ noic=5.4e-12              em=3.0e07                 ef=1.094
+ minr=1e-60                imax=0.01                 imelt=0.01

     4: type=p
+ lmin=3.0e-007             lmax=5.000e-07-dxlp3-dlmis
+ wmin=1.0000e-05-dxwp3-dwmis                         wmax=900.001e-6
+ tnom=25.0                 version=3.24              tox=toxp3+toxmis
+ toxm=6.77e-09             xj=1.7000001e-07          nch=4.9500000e17
+ lln=-1                    lwn=1.0000000             wln=1.0000000
+ wwn=1.0000000             lint=3.5000000e-08        ll=0.00
+ lw=0.00                   lwl=0.00                  wint=2.0000000e-08
+ wl=0.00                   ww=0.00                   wwl=0.00
+ mobmod=1                  binunit=2                 xl=-0.02e-6+dxlp3+dlmis
+ xw=0.0+dxwp3+dwmis        dwg=0.00                  dwb=0.00
+ ldif=9.00e-08             hdif=hdifp3               rsh=rshp3
+ rd=0                      rs=0                      vth0=-0.7654887+dvthp3+vthmis
+ pvth0=0+dpvthp3           wvth0=0+dwvthp3           lvth0=2.4360313e-08+dlvthp3
+ k1=0.7697587              lk1=4.7337540e-08         k2=0.1288249+dk2p3
+ lk2=-2.8482381e-08+dlk2p3 k3=0.00                   dvt0=0.00
+ dvt1=0.00                 dvt2=0.00                 dvt0w=0.00
+ dvt1w=0.00                dvt2w=0.00                nlx=0.00
+ w0=0.00                   k3b=0.00                  vsat=1.2050377e05+dvsatp3
+ wvsat=0+dwvsatp3          lvsat=-4.3065240e-03      ua=1.2215998e-09
+ lua=-1.7604479e-16        ub=1.0977573e-19          lub=2.5871919e-25
+ uc=-8.9515780e-11         luc=2.6582101e-17         rdsw=9.0000000e02
+ prwb=0.00                 prwg=0.00                 wr=1.0000000
+ u0=1.0026056e-02+du0p3    pu0=0+dpu0p3              wu0=0+dwu0p3
+ lu0=-6.1558890e-11+dlu0p3 a0=1.1557579              la0=-8.6956350e-08
+ keta=-9.8874240e-03       lketa=1.1849141e-09       a1=0.00
+ a2=0.9900000              ags=2.0000000e-02         b0=0.00
+ b1=0.00                   voff=-0.1251169+dvoffp3   pvoff=0+dpvoffp3
+ wvoff=0+dwvoffp3          lvoff=8.6701580e-09+dlvoffp3
+ nfactor=1.0000000+dnfactorp3                        pnfactor=0+dpnfactorp3
+ wnfactor=0+dwnfactorp3    lnfactor=0+dlnfactorp3    cit=5.4583350e-04
+ lcit=-1.6337489e-11       cdsc=0.00                 cdscb=0.00
+ cdscd=0.00                eta0=-3.2014790e-04+deta0p3
+ peta0=0+dpeta0p3          weta0=0+dweta0p3          leta0=1.7226064e-10+dleta0p3
+ etab=8.4486390e-04        letab=-3.8739420e-10      dsub=0.00
+ pclm=0.6685342            lpclm=6.6371640e-09       pdiblc1=1.0000000e-06
+ pdiblc2=-3.1977270e-03    lpdiblc2=1.7210681e-09    pdiblcb=1.0000000e-02
+ drout=0.00                pscbe1=3.2899260e08       lpscbe1=8.6130450
+ pscbe2=5.0000000e-07      pvag=0.00                 delta=1.0000000e-02
+ alpha0=0.00               alpha1=0.143217238        beta0=16.10832
+ kt1=-0.3347960            lkt1=1.3608444e-08        kt2=-3.0659514e-02
+ lkt2=9.0488570e-10        at=-5.0000000e04          ute=-0.1691541
+ lute=-1.8071982e-07       ua1=3.4398240e-09         lua1=-5.7761800e-16
+ ub1=-2.4997837e-18        lub1=1.7707251e-25        uc1=5.3556920e-11
+ luc1=-1.0695066e-17       kt1l=0.00                 prt=0
+ cj=cjp3                   pb=0.8049122              mj=0.3954951
+ cjsw=cjswp3               pbsw=0.8049122            mjsw=0.2573111
+ cjswg=cjswgp3             pbswg=0.8049122           mjswg=0.2573111
+ cgdo=cgop3                cgso=cgop3                tcj=0.0009940197
+ tcjsw=0.0006908749        tcjswg=0.0006908749       tpb=0.001625007
+ tpbsw=0.001625007         tpbswg=0.001625007        js=1.900e-07
+ jsw=1.00e-12              n=1                       xti=3
+ capmod=3                  nqsmod=0                  xpart=1
+ cf=0                      tlev=1                    tlevc=1
+ llc=-0.0165               noimod=2                  noia=2.0e19
+ noib=8.0e03               noic=5.4e-12              em=3.0e07
+ ef=1.094                  minr=1e-60                imax=0.01
+ imelt=0.01

     5: type=p
+ lmin=1.000e-05-dxlp3-dlmis                          lmax=20.001e-006
+ wmin=1.2000e-06-dxwp3-dwmis                         wmax=1.0000e-05-dxwp3-dwmis
+ tnom=25.0                 version=3.24              tox=toxp3+toxmis
+ toxm=6.77e-09             xj=1.7000001e-07          nch=4.9500000e17
+ lln=-1                    lwn=1.0000000             wln=1.0000000
+ wwn=1.0000000             lint=3.5000000e-08        ll=0.00
+ lw=0.00                   lwl=0.00                  wint=2.0000000e-08
+ wl=0.00                   ww=0.00                   wwl=0.00
+ mobmod=1                  binunit=2                 xl=-0.02e-6+dxlp3+dlmis
+ xw=0.0+dxwp3+dwmis        dwg=0.00                  dwb=0.00
+ ldif=9.00e-08             hdif=hdifp3               rsh=rshp3
+ rd=0                      rs=0                      vth0=-0.6984460+dvthp3+vthmis
+ pvth0=0+dpvthp3           lvth0=0+dlvthp3           wvth0=6.9768680e-09+dwvthp3
+ k1=0.8503587              wk1=1.0315638e-08         k2=7.3487820e-02+dk2p3
+ lk2=0+dlk2p3              wk2=-2.5573503e-09        k3=0.00
+ dvt0=0.00                 dvt1=0.00                 dvt2=0.00
+ dvt0w=0.00                dvt1w=0.00                dvt2w=0.00
+ nlx=0.00                  w0=0.00                   k3b=0.00
+ vsat=1.5000002e05+dvsatp3 wvsat=0+dwvsatp3          ua=1.6894739e-09
+ wua=-1.0194988e-16        ub=3.0589336e-19          wub=-2.9683633e-25
+ uc=-9.9785820e-11         wuc=-6.4985050e-17        rdsw=9.0000000e02
+ prwb=0.00                 prwg=0.00                 wr=1.0000000
+ u0=1.3156584e-02+du0p3    pu0=0+dpu0p3              lu0=0+dlu0p3
+ wu0=-7.7172380e-10+dwu0p3 a0=0.9693438              wa0=3.2530650e-08
+ keta=1.9776296e-02        wketa=-1.9673381e-09      a1=0.00
+ a2=0.9900000              ags=2.0000000e-02         b0=0.00
+ b1=0.00                   voff=-0.1118388+dvoffp3   pvoff=0+dpvoffp3
+ lvoff=0+dlvoffp3          wvoff=-8.5173270e-10+dwvoffp3
+ nfactor=1.0000000+dnfactorp3                        pnfactor=0+dpnfactorp3
+ wnfactor=0+dwnfactorp3    lnfactor=0+dlnfactorp3    cit=4.5291100e-04
+ wcit=8.0838530e-12        cdsc=0.00                 cdscb=0.00
+ cdscd=0.00                eta0=1.0000000e-05+deta0p3
+ peta0=0+dpeta0p3          weta0=0+dweta0p3          leta0=0+dleta0p3
+ etab=-1.0000000e-05       dsub=0.00                 pclm=0.5000001
+ pdiblc1=1.0000000e-06     pdiblc2=1.0000000e-05     pdiblcb=1.0000000e-02
+ drout=0.00                pscbe1=2.0000003e08       pscbe2=5.0000000e-07
+ pvag=0.00                 delta=1.0000000e-02       alpha0=0.00
+ alpha1=0.143217238        beta0=16.10832            kt1=-0.2916738
+ wkt1=3.7208530e-09        kt2=-2.5821852e-02        wkt2=-6.8693400e-10
+ at=-5.0000000e04          ute=-0.8086289            wute=1.2628378e-07
+ ua1=2.0310000e-09         ub1=-2.6415932e-18        wub1=1.8323023e-25
+ uc1=4.3590560e-12         wuc1=5.0558750e-17        kt1l=0.00
+ prt=0                     cj=cjp3                   pb=0.8049122
+ mj=0.3954951              cjsw=cjswp3               pbsw=0.8049122
+ mjsw=0.2573111            cjswg=cjswgp3             pbswg=0.8049122
+ mjswg=0.2573111           cgdo=cgop3                cgso=cgop3
+ tcj=0.0009940197          tcjsw=0.0006908749        tcjswg=0.0006908749
+ tpb=0.001625007           tpbsw=0.001625007         tpbswg=0.001625007
+ js=1.900e-07              jsw=1.00e-12              n=1
+ xti=3                     capmod=3                  nqsmod=0
+ xpart=1                   cf=0                      tlev=1
+ tlevc=1                   llc=-0.0165               noimod=2
+ noia=2.0e19               noib=8.0e03               noic=5.4e-12
+ em=3.0e07                 ef=1.094                  minr=1e-60
+ imax=0.01                 imelt=0.01

     6: type=p
+ lmin=1.200e-06-dxlp3-dlmis                          lmax=1.000e-05-dxlp3-dlmis
+ wmin=1.2000e-06-dxwp3-dwmis                         wmax=1.0000e-05-dxwp3-dwmis
+ tnom=25.0                 version=3.24              tox=toxp3+toxmis
+ toxm=6.77e-09             xj=1.7000001e-07          nch=4.9500000e17
+ lln=-1                    lwn=1.0000000             wln=1.0000000
+ wwn=1.0000000             lint=3.5000000e-08        ll=0.00
+ lw=0.00                   lwl=0.00                  wint=2.0000000e-08
+ wl=0.00                   ww=0.00                   wwl=0.00
+ mobmod=1                  binunit=2                 xl=-0.02e-6+dxlp3+dlmis
+ xw=0.0+dxwp3+dwmis        dwg=0.00                  dwb=0.00
+ ldif=9.00e-08             hdif=hdifp3               rsh=rshp3
+ rd=0                      rs=0                      vth0=-0.6973685+dvthp3+vthmis
+ lvth0=-1.0678359e-08+dlvthp3                        wvth0=7.1662300e-09+dwvthp3
+ pvth0=-1.8765835e-15+dpvthp3                        k1=0.8484218
+ lk1=1.9194855e-08         wk1=1.1689406e-08         pk1=-1.3614034e-14
+ k2=7.4132180e-02+dk2p3    lk2=-6.3856390e-09+dlk2p3 wk2=-2.8581482e-09
+ pk2=2.9809131e-15         k3=0.00                   dvt0=0.00
+ dvt1=0.00                 dvt2=0.00                 dvt0w=0.00
+ dvt1w=0.00                dvt2w=0.00                nlx=0.00
+ w0=0.00                   k3b=0.00                  vsat=1.5378411e05+dvsatp3
+ wvsat=0+dwvsatp3          lvsat=-3.7500340e-02      ua=1.7025260e-09
+ lua=-1.2934621e-16        wua=-1.2229349e-16        pua=2.0160552e-22
+ ub=2.9719795e-19          lub=8.6171280e-26         wub=-2.8674966e-25
+ pub=-9.9958690e-32        uc=-1.0189776e-10         luc=2.0929388e-17
+ wuc=-6.3469690e-17        puc=-1.5017275e-23        rdsw=9.0000000e02
+ prwb=0.00                 prwg=0.00                 wr=1.0000000
+ u0=1.3313532e-02+du0p3    lu0=-1.5553542e-09+dlu0p3 wu0=-8.0194040e-10+dwu0p3
+ pu0=2.9944828e-16+dpu0p3  a0=0.9772012              la0=-7.7866310e-08
+ wa0=3.5253190e-08         pa0=-2.6980386e-14        keta=2.0953476e-02
+ lketa=-1.1665868e-08      wketa=-2.0108260e-09      pketa=4.3096390e-16
+ a1=0.00                   a2=0.9900000              ags=2.0000000e-02
+ b0=0.00                   b1=0.00                   voff=-0.1118283+dvoffp3
+ lvoff=-1.0463946e-10+dlvoffp3                       wvoff=-7.1421570e-10+dwvoffp3
+ pvoff=-1.3627949e-15+dpvoffp3                       nfactor=1.0000000+dnfactorp3
+ pnfactor=0+dpnfactorp3    wnfactor=0+dwnfactorp3    lnfactor=0+dlnfactorp3
+ cit=4.4620200e-04         lcit=6.6485910e-11        wcit=1.4275149e-11
+ pcit=-6.1355780e-17       cdsc=0.00                 cdscb=0.00
+ cdscd=0.00                eta0=1.0000000e-05+deta0p3
+ peta0=0+dpeta0p3          weta0=0+dweta0p3          leta0=0+dleta0p3
+ etab=-1.0000000e-05       dsub=0.00                 pclm=0.4849888
+ lpclm=1.4876132e-07       wpclm=-4.7646440e-09      ppclm=4.7216950e-14
+ pdiblc1=1.0000000e-06     pdiblc2=1.0000000e-05     pdiblcb=1.0000000e-02
+ drout=0.00                pscbe1=1.8738640e08       lpscbe1=1.2500110e02
+ pscbe2=5.0000000e-07      pvag=0.00                 delta=1.0000000e-02
+ alpha0=0.00               alpha1=0.143217238        beta0=16.10832
+ kt1=-0.2907380            lkt1=-9.2738370e-09       wkt1=3.0755010e-09
+ pkt1=6.3954390e-15        kt2=-2.5782341e-02        lkt2=-3.9155450e-10
+ wkt2=-8.1155670e-10       pkt2=1.2350112e-15        at=-5.0000000e04
+ ute=-0.8213636            lute=1.2620113e-07        wute=1.2623275e-07
+ pute=5.0573060e-16        ua1=2.0310000e-09         ub1=-2.6567511e-18
+ lub1=1.5021592e-25        wub1=1.9645394e-25        pub1=-1.3104698e-31
+ uc1=2.3076966e-12         luc1=2.0329014e-17        wuc1=4.8635520e-17
+ puc1=1.9059230e-23        kt1l=0.00                 prt=0
+ cj=cjp3                   pb=0.8049122              mj=0.3954951
+ cjsw=cjswp3               pbsw=0.8049122            mjsw=0.2573111
+ cjswg=cjswgp3             pbswg=0.8049122           mjswg=0.2573111
+ cgdo=cgop3                cgso=cgop3                tcj=0.0009940197
+ tcjsw=0.0006908749        tcjswg=0.0006908749       tpb=0.001625007
+ tpbsw=0.001625007         tpbswg=0.001625007        js=1.900e-07
+ jsw=1.00e-12              n=1                       xti=3
+ capmod=3                  nqsmod=0                  xpart=1
+ cf=0                      tlev=1                    tlevc=1
+ llc=-0.0165               noimod=2                  noia=2.0e19
+ noib=8.0e03               noic=5.4e-12              em=3.0e07
+ ef=1.094                  minr=1e-60                imax=0.01
+ imelt=0.01

     7: type=p
+ lmin=5.000e-07-dxlp3-dlmis                          lmax=1.200e-06-dxlp3-dlmis
+ wmin=1.2000e-06-dxwp3-dwmis                         wmax=1.0000e-05-dxwp3-dwmis
+ tnom=25.0                 version=3.24              tox=toxp3+toxmis
+ toxm=6.77e-09             xj=1.7000001e-07          nch=4.9500000e17
+ lln=-1                    lwn=1.0000000             wln=1.0000000
+ wwn=1.0000000             lint=3.5000000e-08        ll=0.00
+ lw=0.00                   lwl=0.00                  wint=2.0000000e-08
+ wl=0.00                   ww=0.00                   wwl=0.00
+ mobmod=1                  binunit=2                 xl=-0.02e-6+dxlp3+dlmis
+ xw=0.0+dxwp3+dwmis        dwg=0.00                  dwb=0.00
+ ldif=9.00e-08             hdif=hdifp3               rsh=rshp3
+ rd=0                      rs=0                      vth0=-0.7063123+dvthp3+vthmis
+ lvth0=-7.5076820e-10+dlvthp3                        wvth0=-3.3938940e-09+dwvthp3
+ pvth0=9.8451550e-15+dpvthp3                         k1=0.8532185
+ lk1=1.3870451e-08         wk1=9.7791290e-09         pk1=-1.1493628e-14
+ k2=7.3774080e-02+dk2p3    lk2=-5.9881520e-09+dlk2p3 wk2=-1.3637474e-09
+ pk2=1.3221279e-15         k3=0.00                   dvt0=0.00
+ dvt1=0.00                 dvt2=0.00                 dvt0w=0.00
+ dvt1w=0.00                dvt2w=0.00                nlx=0.00
+ w0=0.00                   k3b=0.00                  vsat=1.2585714e05+dvsatp3
+ wvsat=0+dwvsatp3          lvsat=-6.5014080e-03      ua=2.0674848e-09
+ lua=-5.3445060e-16        wua=-7.0865140e-17        pua=1.4452005e-22
+ ub=1.2599716e-19          lub=2.7620414e-25         wub=-2.5408411e-25
+ pub=-1.3621745e-31        uc=-1.2225446e-10         luc=4.3525310e-17
+ wuc=-7.2008350e-17        puc=-5.5393540e-24        rdsw=9.0000000e02
+ prwb=0.00                 prwg=0.00                 wr=1.0000000
+ u0=1.3079622e-02+du0p3    lu0=-1.2957146e-09+dlu0p3 wu0=-5.9050560e-10+dwu0p3
+ pu0=6.4755580e-17+dpu0p3  a0=0.8879921              la0=2.1155756e-08
+ wa0=-6.4301090e-09        pa0=1.9288072e-14         keta=2.0470830e-02
+ lketa=-1.1130130e-08      wketa=-6.9703380e-10      pketa=-1.0273464e-15
+ a1=0.00                   a2=0.9900000              ags=2.0000000e-02
+ b0=0.00                   b1=0.00                   voff=-0.1170540+dvoffp3
+ lvoff=5.6959450e-09+dlvoffp3                        wvoff=1.6383606e-09+dwvoffp3
+ pvoff=-3.9741550e-15+dpvoffp3                       nfactor=1.0000000+dnfactorp3
+ pnfactor=0+dpnfactorp3    wnfactor=0+dwnfactorp3    lnfactor=0+dlnfactorp3
+ cit=5.0421500e-04         lcit=2.0914730e-12        wcit=-4.5587650e-11
+ pcit=5.0919230e-18        cdsc=0.00                 cdscb=0.00
+ cdscd=0.00                eta0=-4.2714280e-05+deta0p3
+ peta0=0+dpeta0p3          weta0=0+dweta0p3          leta0=5.8512850e-11+dleta0p3
+ etab=4.2714280e-05        letab=-5.8512850e-11      dsub=0.00
+ pclm=0.5832995            lpclm=3.9636520e-08       wpclm=3.2196260e-08
+ ppclm=6.1903360e-15       pdiblc1=1.0000000e-06     pdiblc2=-5.6985730e-04
+ lpdiblc2=6.4364150e-10    pdiblcb=1.0000000e-02     drout=0.00
+ pscbe1=2.7071427e08       lpscbe1=32.5071400        pscbe2=5.0000000e-07
+ pvag=0.00                 delta=1.0000000e-02       alpha0=0.00
+ alpha1=0.143217238        beta0=16.10832            kt1=-0.2971400
+ lkt1=-2.1676729e-09       wkt1=9.2162620e-09        pkt1=-4.2080570e-16
+ kt2=-2.4722382e-02        lkt2=-1.5681096e-09       wkt2=-7.4258340e-11
+ pkt2=4.1660990e-16        at=-5.0000000e04          ute=-0.7553561
+ lute=5.2932850e-08        wute=1.0569979e-07        pute=2.3297301e-14
+ ua1=2.0310000e-09         ub1=-2.7846704e-18        lub1=2.9220633e-25
+ wub1=1.0055110e-25        pub1=-2.4594843e-32       uc1=1.9397399e-11
+ luc1=1.3594401e-18        wuc1=7.6591040e-17        puc1=-1.1971389e-23
+ kt1l=0.00                 prt=0                     cj=cjp3
+ pb=0.8049122              mj=0.3954951              cjsw=cjswp3
+ pbsw=0.8049122            mjsw=0.2573111            cjswg=cjswgp3
+ pbswg=0.8049122           mjswg=0.2573111           cgdo=cgop3
+ cgso=cgop3                tcj=0.0009940197          tcjsw=0.0006908749
+ tcjswg=0.0006908749       tpb=0.001625007           tpbsw=0.001625007
+ tpbswg=0.001625007        js=1.900e-07              jsw=1.00e-12
+ n=1                       xti=3                     capmod=3
+ nqsmod=0                  xpart=1                   cf=0
+ tlev=1                    tlevc=1                   llc=-0.0165
+ noimod=2                  noia=2.0e19               noib=8.0e03
+ noic=5.4e-12              em=3.0e07                 ef=1.094
+ minr=1e-60                imax=0.01                 imelt=0.01

     8: type=p
+ lmin=3.0e-007             lmax=5.000e-07-dxlp3-dlmis
+ wmin=1.2000e-06-dxwp3-dwmis                         wmax=1.0000e-05-dxwp3-dwmis
+ tnom=25.0                 version=3.24              tox=toxp3+toxmis
+ toxm=6.77e-09             xj=1.7000001e-07          nch=4.9500000e17
+ lln=-1                    lwn=1.0000000             wln=1.0000000
+ wwn=1.0000000             lint=3.5000000e-08        ll=0.00
+ lw=0.00                   lwl=0.00                  wint=2.0000000e-08
+ wl=0.00                   ww=0.00                   wwl=0.00
+ mobmod=1                  binunit=2                 xl=-0.02e-6+dxlp3+dlmis
+ xw=0.0+dxwp3+dwmis        dwg=0.00                  dwb=0.00
+ ldif=9.00e-08             hdif=hdifp3               rsh=rshp3
+ rd=0                      rs=0                      vth0=-0.7727100+dvthp3+vthmis
+ lvth0=2.6472314e-08+dlvthp3                         wvth0=7.1924870e-08+dwvthp3
+ pvth0=-2.1035541e-14+dpvthp3                        k1=0.7699419
+ lk1=4.8013860e-08         wk1=-1.8243896e-09        pk1=-6.7361810e-15
+ k2=0.1315423+dk2p3        lk2=-2.9673100e-08+dlk2p3 wk2=-2.7064845e-08
+ pk2=1.1859575e-14         k3=0.00                   dvt0=0.00
+ dvt1=0.00                 dvt2=0.00                 dvt0w=0.00
+ dvt1w=0.00                dvt2w=0.00                nlx=0.00
+ w0=0.00                   k3b=0.00                  vsat=1.1960348e05+dvsatp3
+ lvsat=-3.9374090e-03      wvsat=8.9667880e-03+dwvsatp3
+ pvsat=-3.6763830e-09      ua=1.1489469e-09          lua=-1.5785002e-16
+ wua=7.2362290e-16         pua=-1.8122008e-22        ub=2.4514955e-19
+ lub=2.2735166e-25         wub=-1.3483237e-24        pub=3.1242082e-31
+ uc=-7.1838280e-11         luc=2.2854683e-17         wuc=-1.7606797e-16
+ puc=3.7125090e-23         rdsw=9.0000000e02         prwb=0.00
+ prwg=0.00                 wr=1.0000000              u0=1.0090719e-02+du0p3
+ lu0=-7.0264360e-11+dlu0p3 wu0=-6.4404460e-10+dwu0p3 pu0=8.6706510e-17+dpu0p3
+ a0=1.1409379              la0=-8.2552040e-08        wa0=1.4760643e-07
+ pa0=-4.3866910e-14        keta=-1.1318877e-02       lketa=1.9036506e-09
+ wketa=1.4257295e-08       pketa=-7.1586210e-15      a1=0.00
+ a2=0.9900000              ags=2.0000000e-02         b0=0.00
+ b1=0.00                   voff=-0.1250223+dvoffp3   lvoff=8.9629090e-09+dlvoffp3
+ wvoff=-9.4300550e-10+dwvoffp3                       pvoff=-2.9157947e-15+dpvoffp3
+ nfactor=1.0000000+dnfactorp3                        pnfactor=0+dpnfactorp3
+ wnfactor=0+dwnfactorp3    lnfactor=0+dlnfactorp3    cit=5.6188450e-04
+ lcit=-2.1553027e-11       wcit=-1.5986783e-10       pcit=5.1946790e-17
+ cdsc=0.00                 cdscb=0.00                cdscd=0.00
+ eta0=-2.8413706e-04+deta0p3                         leta0=1.5749620e-10+dleta0p3
+ weta0=-3.5866790e-10+dweta0p3                       peta0=1.4705383e-16+dpeta0p3
+ etab=8.7586620e-04        letab=-4.0010520e-10      wetab=-3.0878400e-10
+ petab=1.2660141e-16       dsub=0.00                 pclm=0.6645077
+ lpclm=6.3411240e-09       wpclm=4.0103030e-08       ppclm=2.9485615e-15
+ pdiblc1=1.0000000e-06     pdiblc2=-3.7510620e-03    lpdiblc2=1.9479358e-09
+ wpdiblc2=5.5112340e-09    ppdiblc2=-2.2596061e-15   pdiblcb=1.0000000e-02
+ drout=0.00                pscbe1=3.3079310e08       lpscbe1=7.8748250
+ wpscbe1=-17.9333440       ppscbe1=7.3526710e-06     pscbe2=5.0000000e-07
+ pvag=0.00                 delta=1.0000000e-02       alpha0=0.00
+ alpha1=0.143217238        beta0=16.10832            kt1=-0.3349694
+ lkt1=1.3342398e-08        wkt1=1.7269201e-09        pkt1=2.6498244e-15
+ kt2=-3.0737475e-02        lkt2=8.9807820e-10        wkt2=7.7649210e-10
+ pkt2=6.7802250e-17        at=-5.0000000e04          ute=-0.1318164
+ lute=-2.0271844e-07       wute=-3.7188310e-07       pute=2.1910628e-13
+ ua1=3.6255330e-09         lua1=-6.5375860e-16       wua1=-1.8496589e-15
+ pua1=7.5836000e-22        ub1=-2.5613780e-18        lub1=2.0065643e-25
+ wub1=6.1348050e-25        pub1=-2.3489589e-31       uc1=4.8751200e-11
+ luc1=-1.0675619e-17       wuc1=4.7864960e-17        puc1=-1.9370043e-25
+ kt1l=0.00                 prt=0                     cj=cjp3
+ pb=0.8049122              mj=0.3954951              cjsw=cjswp3
+ pbsw=0.8049122            mjsw=0.2573111            cjswg=cjswgp3
+ pbswg=0.8049122           mjswg=0.2573111           cgdo=cgop3
+ cgso=cgop3                tcj=0.0009940197          tcjsw=0.0006908749
+ tcjswg=0.0006908749       tpb=0.001625007           tpbsw=0.001625007
+ tpbswg=0.001625007        js=1.900e-07              jsw=1.00e-12
+ n=1                       xti=3                     capmod=3
+ nqsmod=0                  xpart=1                   cf=0
+ tlev=1                    tlevc=1                   llc=-0.0165
+ noimod=2                  noia=2.0e19               noib=8.0e03
+ noic=5.4e-12              em=3.0e07                 ef=1.094
+ minr=1e-60                imax=0.01                 imelt=0.01

     9: type=p
+ lmin=1.000e-05-dxlp3-dlmis                          lmax=20.001e-006
+ wmin=5.0000e-07-dxwp3-dwmis                         wmax=1.2000e-06-dxwp3-dwmis
+ tnom=25.0                 version=3.24              tox=toxp3+toxmis
+ toxm=6.77e-09             xj=1.7000001e-07          nch=4.9500000e17
+ lln=-1                    lwn=1.0000000             wln=1.0000000
+ wwn=1.0000000             lint=3.5000000e-08        ll=0.00
+ lw=0.00                   lwl=0.00                  wint=2.0000000e-08
+ wl=0.00                   ww=0.00                   wwl=0.00
+ mobmod=1                  binunit=2                 xl=-0.02e-6+dxlp3+dlmis
+ xw=0.0+dxwp3+dwmis        dwg=0.00                  dwb=0.00
+ ldif=9.00e-08             hdif=hdifp3               rsh=rshp3
+ rd=0                      rs=0                      vth0=-0.6992865+dvthp3+vthmis
+ pvth0=0+dpvthp3           lvth0=0+dlvthp3           wvth0=7.9518050e-09+dwvthp3
+ k1=0.8536492              wk1=6.4986320e-09         k2=7.3503040e-02+dk2p3
+ lk2=0+dlk2p3              wk2=-2.5750040e-09        k3=0.00
+ dvt0=0.00                 dvt1=0.00                 dvt2=0.00
+ dvt0w=0.00                dvt1w=0.00                dvt2w=0.00
+ nlx=0.00                  w0=0.00                   k3b=0.00
+ vsat=1.5000002e05+dvsatp3 wvsat=0+dwvsatp3          ua=2.3221998e-09
+ wua=-8.3591190e-16        ub=5.0000000e-20          uc=-1.3989673e-10
+ wuc=-1.8456393e-17        rdsw=9.0000000e02         prwb=0.00
+ prwg=0.00                 wr=1.0000000              u0=1.4610297e-02+du0p3
+ pu0=0+dpu0p3              lu0=0+dlu0p3              wu0=-2.4580307e-09+dwu0p3
+ a0=0.9420360              wa0=6.4207830e-08         keta=1.8767053e-02
+ wketa=-7.9661680e-10      a1=0.00                   a2=0.9900000
+ ags=2.0000001e-02         b0=0.00                   b1=0.00
+ voff=-0.1126554+dvoffp3   pvoff=0+dpvoffp3          lvoff=0+dlvoffp3
+ wvoff=9.5426480e-11+dwvoffp3                        nfactor=1.0000000+dnfactorp3
+ pnfactor=0+dpnfactorp3    wnfactor=0+dwnfactorp3    lnfactor=0+dlnfactorp3
+ cit=4.8056380e-04         wcit=-2.3993458e-11       cdsc=0.00
+ cdscb=0.00                cdscd=0.00                eta0=1.0000000e-05+deta0p3
+ peta0=0+dpeta0p3          weta0=0+dweta0p3          leta0=0+dleta0p3
+ etab=-1.0000000e-05       dsub=0.00                 pclm=0.5000000
+ pdiblc1=1.0000000e-06     pdiblc2=1.0000000e-05     pdiblcb=1.0000000e-02
+ drout=0.00                pscbe1=2.0000003e08       pscbe2=5.0000000e-07
+ pvag=0.00                 delta=1.0000000e-02       alpha0=0.00
+ alpha1=0.143217238        beta0=16.10832            kt1=-0.2917677
+ wkt1=3.8297360e-09        kt2=-2.7259111e-02        wkt2=9.8028660e-10
+ at=-5.0000000e04          ute=-0.7662017            wute=7.7068240e-08
+ ua1=2.0309998e-09         ub1=-2.5738963e-18        wub1=1.0470186e-25
+ uc1=4.6204500e-11         wuc1=2.0180378e-18        kt1l=0.00
+ prt=0                     cj=cjp3                   pb=0.8049122
+ mj=0.3954951              cjsw=cjswp3               pbsw=0.8049122
+ mjsw=0.2573111            cjswg=cjswgp3             pbswg=0.8049122
+ mjswg=0.2573111           cgdo=cgop3                cgso=cgop3
+ tcj=0.0009940197          tcjsw=0.0006908749        tcjswg=0.0006908749
+ tpb=0.001625007           tpbsw=0.001625007         tpbswg=0.001625007
+ js=1.900e-07              jsw=1.00e-12              n=1
+ xti=3                     capmod=3                  nqsmod=0
+ xpart=1                   cf=0                      tlev=1
+ tlevc=1                   llc=-0.0165               noimod=2
+ noia=2.0e19               noib=8.0e03               noic=5.4e-12
+ em=3.0e07                 ef=1.094                  minr=1e-60
+ imax=0.01                 imelt=0.01

     10: type=p
+ lmin=1.200e-06-dxlp3-dlmis                          lmax=1.000e-05-dxlp3-dlmis
+ wmin=5.0000e-07-dxwp3-dwmis                         wmax=1.2000e-06-dxwp3-dwmis
+ tnom=25.0                 version=3.24              tox=toxp3+toxmis
+ toxm=6.77e-09             xj=1.7000001e-07          nch=4.9500000e17
+ lln=-1                    lwn=1.0000000             wln=1.0000000
+ wwn=1.0000000             lint=3.5000000e-08        ll=0.00
+ lw=0.00                   lwl=0.00                  wint=2.0000000e-08
+ wl=0.00                   ww=0.00                   wwl=0.00
+ mobmod=1                  binunit=2                 xl=-0.02e-6+dxlp3+dlmis
+ xw=0.0+dxwp3+dwmis        dwg=0.00                  dwb=0.00
+ ldif=9.00e-08             hdif=hdifp3               rsh=rshp3
+ rd=0                      rs=0                      vth0=-0.6977277+dvthp3+vthmis
+ lvth0=-1.5447748e-08+dlvthp3                        wvth0=7.5828930e-09+dwvthp3
+ pvth0=3.6559090e-15+dpvthp3                         k1=0.8533953
+ lk1=2.5154285e-09         wk1=5.9200140e-09         pk1=5.7341030e-15
+ k2=7.3639660e-02+dk2p3    lk2=-1.3539118e-09+dlk2p3 wk2=-2.2868212e-09
+ pk2=-2.8558914e-15        k3=0.00                   dvt0=0.00
+ dvt1=0.00                 dvt2=0.00                 dvt0w=0.00
+ dvt1w=0.00                dvt2w=0.00                nlx=0.00
+ w0=0.00                   k3b=0.00                  vsat=1.5378411e05+dvsatp3
+ wvsat=0+dwvsatp3          lvsat=-3.7500340e-02      ua=2.3145617e-09
+ lua=7.5691840e-17         wua=-8.3225500e-16        pua=-3.6238470e-23
+ ub=5.0000000e-20          uc=-1.4156483e-10         luc=1.6530885e-17
+ wuc=-1.7455885e-17        puc=-9.9150150e-24        rdsw=9.0000000e02
+ prwb=0.00                 prwg=0.00                 wr=1.0000000
+ u0=1.4772911e-02+du0p3    lu0=-1.6115109e-09+dlu0p3 wu0=-2.4948206e-09+dwu0p3
+ pu0=3.6459010e-16+dpu0p3  a0=0.9551688              la0=-1.3014645e-07
+ wa0=6.0810790e-08         pa0=3.3664580e-14         keta=1.9918669e-02
+ lketa=-1.1412505e-08      wketa=-8.1044770e-10      pketa=1.3706199e-16
+ a1=0.00                   a2=0.9900000              ags=1.9607194e-02
+ lags=3.8927150e-09        wags=4.5565450e-10        pags=-4.5155490e-15
+ b0=0.00                   b1=0.00                   voff=-0.1124224+dvoffp3
+ lvoff=-2.3088516e-09+dlvoffp3                       wvoff=-2.5067145e-11+dwvoffp3
+ pvoff=1.1940914e-15+dpvoffp3                        nfactor=1.0000000+dnfactorp3
+ pnfactor=0+dpnfactorp3    wnfactor=0+dwnfactorp3    lnfactor=0+dlnfactorp3
+ cit=4.8383600e-04         lcit=-3.2427540e-11       wcit=-2.9380325e-11
+ pcit=5.3383830e-17        cdsc=0.00                 cdscb=0.00
+ cdscd=0.00                eta0=1.0000000e-05+deta0p3
+ peta0=0+dpeta0p3          weta0=0+dweta0p3          leta0=0+dleta0p3
+ etab=-1.0000000e-05       dsub=0.00                 pclm=0.4848956
+ lpclm=1.4968438e-07       wpclm=-4.6565580e-09      ppclm=4.6146210e-14
+ pdiblc1=1.0000000e-06     pdiblc2=1.0000000e-05     pdiblcb=1.0000000e-02
+ drout=0.00                pscbe1=1.8738640e08       lpscbe1=1.2500110e02
+ pscbe2=5.0000000e-07      pvag=0.00                 delta=1.0000000e-02
+ alpha0=0.00               alpha1=0.143217238        beta0=16.10832
+ kt1=-0.2911539            lkt1=-6.0821800e-09       wkt1=3.5579780e-09
+ pkt1=2.6931163e-15        kt2=-2.7373781e-02        lkt2=1.1363845e-09
+ wkt2=1.0345145e-09        pkt2=-5.3739830e-16       at=-5.0000000e04
+ ute=-0.7822405            lute=1.5894491e-07        wute=8.0849990e-08
+ pute=-3.7477070e-14       ua1=2.0253581e-09         lua1=5.5907670e-17
+ wua1=6.5445300e-18        pua1=-6.4852900e-23       ub1=-2.5749808e-18
+ lub1=1.0747389e-26        wub1=1.0160029e-25        pub1=3.0736538e-32
+ uc1=4.3742250e-11         luc1=2.4400898e-17        wuc1=5.7143320e-19
+ puc1=1.4335845e-23        kt1l=0.00                 prt=0
+ cj=cjp3                   pb=0.8049122              mj=0.3954951
+ cjsw=cjswp3               pbsw=0.8049122            mjsw=0.2573111
+ cjswg=cjswgp3             pbswg=0.8049122           mjswg=0.2573111
+ cgdo=cgop3                cgso=cgop3                tcj=0.0009940197
+ tcjsw=0.0006908749        tcjswg=0.0006908749       tpb=0.001625007
+ tpbsw=0.001625007         tpbswg=0.001625007        js=1.900e-07
+ jsw=1.00e-12              n=1                       xti=3
+ capmod=3                  nqsmod=0                  xpart=1
+ cf=0                      tlev=1                    tlevc=1
+ llc=-0.0165               noimod=2                  noia=2.0e19
+ noib=8.0e03               noic=5.4e-12              em=3.0e07
+ ef=1.094                  minr=1e-60                imax=0.01
+ imelt=0.01

     11: type=p
+ lmin=5.000e-07-dxlp3-dlmis                          lmax=1.200e-06-dxlp3-dlmis
+ wmin=5.0000e-07-dxwp3-dwmis                         wmax=1.2000e-06-dxwp3-dwmis
+ tnom=25.0                 version=3.24              tox=toxp3+toxmis
+ toxm=6.77e-09             xj=1.7000001e-07          nch=4.9500000e17
+ lln=-1                    lwn=1.0000000             wln=1.0000000
+ wwn=1.0000000             lint=3.5000000e-08        ll=0.00
+ lw=0.00                   lwl=0.00                  wint=2.0000000e-08
+ wl=0.00                   ww=0.00                   wwl=0.00
+ mobmod=1                  binunit=2                 xl=-0.02e-6+dxlp3+dlmis
+ xw=0.0+dxwp3+dwmis        dwg=0.00                  dwb=0.00
+ ldif=9.00e-08             hdif=hdifp3               rsh=rshp3
+ rd=0                      rs=0                      vth0=-0.7239643+dvthp3+vthmis
+ lvth0=1.3674838e-08+dlvthp3                         wvth0=1.7082405e-08+dwvthp3
+ pvth0=-6.8885490e-15+dpvthp3                        k1=0.8600600
+ lk1=-4.8823770e-09        wk1=1.8429434e-09         pk1=1.0259654e-14
+ k2=7.5423550e-02+dk2p3    lk2=-3.3340390e-09+dlk2p3 wk2=-3.2771350e-09
+ pk2=-1.7566433e-15        k3=0.00                   dvt0=0.00
+ dvt1=0.00                 dvt2=0.00                 dvt0w=0.00
+ dvt1w=0.00                dvt2w=0.00                nlx=0.00
+ w0=0.00                   k3b=0.00                  vsat=1.2585714e05+dvsatp3
+ wvsat=0+dwvsatp3          lvsat=-6.5014090e-03      ua=2.9925082e-09
+ lua=-6.7682880e-16        wua=-1.1438922e-15        pua=3.0967882e-22
+ ub=-1.8703899e-19         lub=2.6311331e-25         wub=1.0903794e-25
+ pub=-1.2103212e-31        uc=-1.7420571e-10         luc=5.2762270e-17
+ wuc=-1.1744898e-17        puc=-1.6254219e-23        rdsw=9.0000000e02
+ prwb=0.00                 prwg=0.00                 wr=1.0000000
+ u0=1.5154593e-02+du0p3    lu0=-2.0351774e-09+dlu0p3 wu0=-2.9974716e-09+dwu0p3
+ pu0=9.2253250e-16+dpu0p3  a0=0.7949075              la0=4.7743620e-08
+ wa0=1.0154811e-07         pa0=-1.1553848e-14        keta=2.1075293e-02
+ lketa=-1.2696355e-08      wketa=-1.3982078e-09      pketa=7.8947390e-16
+ a1=0.00                   a2=0.9900000              ags=2.3456581e-02
+ lags=-3.8010610e-10       wags=-4.0096360e-09       pags=4.4092310e-16
+ b0=0.00                   b1=0.00                   voff=-0.1131885+dvoffp3
+ lvoff=-1.4584653e-09+dlvoffp3                       wvoff=-2.8456701e-09+dwvoffp3
+ pvoff=4.3249610e-15+dpvoffp3                        nfactor=1.0000000+dnfactorp3
+ pnfactor=0+dpnfactorp3    wnfactor=0+dwnfactorp3    lnfactor=0+dlnfactorp3
+ cit=4.4694590e-04         lcit=8.5205100e-12        wcit=2.0844531e-11
+ pcit=-2.3657607e-18       cdsc=0.00                 cdscb=0.00
+ cdscd=0.00                eta0=-4.2714290e-05+deta0p3
+ peta0=0+dpeta0p3          weta0=0+dweta0p3          leta0=5.8512870e-11+dleta0p3
+ etab=4.2714290e-05        letab=-5.8512870e-11      dsub=0.00
+ pclm=0.5728803            lpclm=5.2021480e-08       wpclm=4.4282560e-08
+ ppclm=-8.1762150e-15      pdiblc1=1.0000000e-06     pdiblc2=-5.6985730e-04
+ lpdiblc2=6.4364150e-10    pdiblcb=1.0000000e-02     drout=0.00
+ pscbe1=2.7071427e08       lpscbe1=32.5071400        pscbe2=5.0000000e-07
+ pvag=0.00                 delta=1.0000000e-02       alpha0=0.00
+ alpha1=0.143217238        beta0=16.10832            kt1=-0.2933006
+ lkt1=-3.6994080e-09       wkt1=4.7625810e-09        pkt1=1.3560070e-15
+ kt2=-2.3266830e-02        lkt2=-3.4223340e-09       wkt2=-1.7626999e-09
+ pkt2=2.5675102e-15        at=-5.0000000e04          ute=-0.7077559
+ lute=7.6267040e-08        wute=5.0483580e-08        pute=-3.7703630e-15
+ ua1=2.1019217e-09         lua1=-2.9077913e-17       wua1=-8.2269240e-17
+ pua1=3.3730390e-23        ub1=-2.8656773e-18        lub1=3.3342050e-25
+ wub1=1.9451905e-25        pub1=-7.2403270e-32       uc1=7.5798370e-11
+ luc1=-1.1181404e-17       wuc1=1.1165895e-17        puc1=2.5759914e-24
+ kt1l=0.00                 prt=0                     cj=cjp3
+ pb=0.8049122              mj=0.3954951              cjsw=cjswp3
+ pbsw=0.8049122            mjsw=0.2573111            cjswg=cjswgp3
+ pbswg=0.8049122           mjswg=0.2573111           cgdo=cgop3
+ cgso=cgop3                tcj=0.0009940197          tcjsw=0.0006908749
+ tcjswg=0.0006908749       tpb=0.001625007           tpbsw=0.001625007
+ tpbswg=0.001625007        js=1.900e-07              jsw=1.00e-12
+ n=1                       xti=3                     capmod=3
+ nqsmod=0                  xpart=1                   cf=0
+ tlev=1                    tlevc=1                   llc=-0.0165
+ noimod=2                  noia=2.0e19               noib=8.0e03
+ noic=5.4e-12              em=3.0e07                 ef=1.094
+ minr=1e-60                imax=0.01                 imelt=0.01

     12: type=p
+ lmin=3.0e-007             lmax=5.000e-07-dxlp3-dlmis
+ wmin=5.0000e-07-dxwp3-dwmis                         wmax=1.2000e-06-dxwp3-dwmis
+ tnom=25.0                 version=3.24              tox=toxp3+toxmis
+ toxm=6.77e-09             xj=1.7000001e-07          nch=4.9500000e17
+ lln=-1                    lwn=1.0000000             wln=1.0000000
+ wwn=1.0000000             lint=3.5000000e-08        ll=0.00
+ lw=0.00                   lwl=0.00                  wint=2.0000000e-08
+ wl=0.00                   ww=0.00                   wwl=0.00
+ mobmod=1                  binunit=2                 xl=-0.02e-6+dxlp3+dlmis
+ xw=0.0+dxwp3+dwmis        dwg=0.00                  dwb=0.00
+ ldif=9.00e-08             hdif=hdifp3               rsh=rshp3
+ rd=0                      rs=0                      vth0=-0.7091326+dvthp3+vthmis
+ lvth0=7.5938330e-09+dlvthp3                         wvth0=-1.8250328e-09+dwvthp3
+ pvth0=8.6350020e-16+dpvthp3                         k1=0.7124246
+ lk1=5.5648150e-08         wk1=6.4895670e-08         pk1=-1.5591964e-14
+ k2=0.1203709+dk2p3        lk2=-2.1762434e-08+dlk2p3 wk2=-1.4106020e-08
+ pk2=2.6832007e-15         k3=0.00                   dvt0=0.00
+ dvt1=0.00                 dvt2=0.00                 dvt0w=0.00
+ dvt1w=0.00                dvt2w=0.00                nlx=0.00
+ w0=0.00                   k3b=0.00                  vsat=1.2733347e05+dvsatp3
+ wvsat=0+dwvsatp3          lvsat=-7.1067050e-03      ua=2.6204112e-09
+ lua=-5.2426900e-16        wua=-9.8327540e-16        pua=2.4382590e-22
+ ub=-1.5527859e-18         lub=8.2306960e-25         wub=7.3728160e-25
+ pub=-3.7861200e-31        uc=-2.3368188e-10         luc=7.7147500e-17
+ wuc=1.1670629e-17         puc=-2.5854586e-23        rdsw=9.0000000e02
+ prwb=0.00                 prwg=0.00                 wr=1.0000000
+ u0=1.0345819e-02+du0p3    lu0=-6.3580270e-11+dlu0p3 wu0=-9.3996030e-10+dwu0p3
+ pu0=7.8952960e-17+dpu0p3  a0=1.2442838              la0=-1.3650067e-07
+ wa0=2.7725269e-08         pa0=1.8713521e-14         keta=2.4851217e-04
+ lketa=-4.1573760e-09      wketa=8.3911840e-10       pketa=-1.2782924e-16
+ a1=0.00                   a2=0.9900000              ags=2.2341035e-02
+ lags=7.7267680e-11        wags=-2.7156024e-09       pags=-8.9630500e-17
+ b0=0.00                   b1=0.00                   voff=-0.1428125+dvoffp3
+ lvoff=1.0687391e-08+dlvoffp3                        wvoff=1.9693728e-08+dwvoffp3
+ pvoff=-4.9161920e-15+dpvoffp3                       nfactor=1.0000000+dnfactorp3
+ pnfactor=0+dpnfactorp3    wnfactor=0+dwnfactorp3    lnfactor=0+dlnfactorp3
+ cit=4.0186070e-04         lcit=2.7005427e-11        wcit=2.5759807e-11
+ pcit=-4.3810230e-18       cdsc=0.00                 cdscb=0.00
+ cdscd=0.00                eta0=-5.9333350e-04+deta0p3
+ peta0=0+dpeta0p3          weta0=0+dweta0p3          leta0=2.8426675e-10+dleta0p3
+ etab=2.7869639e-04        letab=-1.5526558e-10      wetab=3.8393310e-10
+ petab=-1.5741254e-16      dsub=0.00                 pclm=0.7490969
+ lpclm=-2.0227363e-08      wpclm=-5.8020430e-08      ppclm=3.3768010e-14
+ pdiblc1=1.0000000e-06     pdiblc2=1.0000000e-03     pdiblcb=1.0000000e-02
+ drout=0.00                pscbe1=3.1533334e08       lpscbe1=14.2133340
+ pscbe2=5.0000000e-07      pvag=0.00                 delta=1.0000000e-02
+ alpha0=0.00               alpha1=0.143217238        beta0=16.10832
+ kt1=-0.3549937            lkt1=2.1594769e-08        wkt1=2.4955103e-08
+ pkt1=-6.9229260e-15       kt2=-4.3607630e-02        lkt2=4.9173970e-09
+ wkt2=1.5705877e-08        pkt2=-4.5946070e-15       at=-5.0000000e04
+ ute=-0.4699602            lute=-2.1229209e-08       wute=2.0363800e-08
+ pute=8.5787470e-15        ua1=2.0310000e-09         ub1=-1.9069588e-18
+ lub1=-5.9654050e-26       wub1=-1.4564585e-25       pub1=6.7064330e-32
+ uc1=1.1059081e-10         luc1=-2.5446301e-17       wuc1=-2.3868988e-17
+ puc1=1.6940293e-23        kt1l=0.00                 prt=0
+ cj=cjp3                   pb=0.8049122              mj=0.3954951
+ cjsw=cjswp3               pbsw=0.8049122            mjsw=0.2573111
+ cjswg=cjswgp3             pbswg=0.8049122           mjswg=0.2573111
+ cgdo=cgop3                cgso=cgop3                tcj=0.0009940197
+ tcjsw=0.0006908749        tcjswg=0.0006908749       tpb=0.001625007
+ tpbsw=0.001625007         tpbswg=0.001625007        js=1.900e-07
+ jsw=1.00e-12              n=1                       xti=3
+ capmod=3                  nqsmod=0                  xpart=1
+ cf=0                      tlev=1                    tlevc=1
+ llc=-0.0165               noimod=2                  noia=2.0e19
+ noib=8.0e03               noic=5.4e-12              em=3.0e07
+ ef=1.094                  minr=1e-60                imax=0.01
+ imelt=0.01

     13: type=p
+ lmin=1.000e-05-dxlp3-dlmis                          lmax=20.001e-006
+ wmin=2.2e-007             wmax=5.0000e-07-dxwp3-dwmis
+ tnom=25.0                 version=3.24              tox=toxp3+toxmis
+ toxm=6.77e-09             xj=1.7000001e-07          nch=4.9500000e17
+ lln=-1                    lwn=1.0000000             wln=1.0000000
+ wwn=1.0000000             lint=3.5000000e-08        ll=0.00
+ lw=0.00                   lwl=0.00                  wint=2.0000000e-08
+ wl=0.00                   ww=0.00                   wwl=0.00
+ mobmod=1                  binunit=2                 xl=-0.02e-6+dxlp3+dlmis
+ xw=0.0+dxwp3+dwmis        dwg=0.00                  dwb=0.00
+ ldif=9.00e-08             hdif=hdifp3               rsh=rshp3
+ rd=0                      rs=0                      vth0=-0.6974285+dvthp3+vthmis
+ pvth0=0+dpvthp3           lvth0=0+dlvthp3           wvth0=7.0971400e-09+dwvthp3
+ k1=0.8440637              wk1=1.0907958e-08         k2=7.8954390e-02+dk2p3
+ lk2=0+dlk2p3              wk2=-5.0826280e-09        k3=0.00
+ dvt0=0.00                 dvt1=0.00                 dvt2=0.00
+ dvt0w=0.00                dvt1w=0.00                dvt2w=0.00
+ nlx=0.00                  w0=0.00                   k3b=0.00
+ vsat=1.5000002e05+dvsatp3 wvsat=0+dwvsatp3          ua=5.0500000e-10
+ ub=5.0000000e-20          uc=-1.3973826e-10         wuc=-1.8529287e-17
+ rdsw=9.0000000e02         prwb=0.00                 prwg=0.00
+ wr=1.0000000              u0=7.9532350e-03+du0p3    pu0=0+dpu0p3
+ lu0=0+dlu0p3              wu0=6.0421770e-10+dwu0p3  a0=1.0130361
+ wa0=3.1547767e-08         keta=1.8505057e-02        wketa=-6.7609830e-10
+ a1=0.00                   a2=0.9900000              ags=1.9999994e-02
+ b0=0.00                   b1=0.00                   voff=-0.1076706+dvoffp3
+ pvoff=0+dpvoffp3          lvoff=0+dlvoffp3          wvoff=-2.1975590e-09+dwvoffp3
+ nfactor=1.0000000+dnfactorp3                        pnfactor=0+dpnfactorp3
+ wnfactor=0+dwnfactorp3    lnfactor=0+dlnfactorp3    cit=1.0026426e-03
+ wcit=-2.6414965e-10       cdsc=0.00                 cdscb=0.00
+ cdscd=0.00                eta0=1.0000000e-05+deta0p3
+ peta0=0+dpeta0p3          weta0=0+dweta0p3          leta0=0+dleta0p3
+ etab=-1.0000000e-05       dsub=0.00                 pclm=0.5000000
+ pdiblc1=1.0000000e-06     pdiblc2=1.0000000e-05     pdiblcb=1.0000000e-02
+ drout=0.00                pscbe1=2.0000003e08       pscbe2=5.0000000e-07
+ pvag=0.00                 delta=1.0000000e-02       alpha0=0.00
+ alpha1=0.143217238        beta0=16.10832            kt1=-0.2896371
+ wkt1=2.8496747e-09        kt2=-2.7464394e-02        wkt2=1.0747162e-09
+ at=-5.0000000e04          ute=-0.6117741            wute=6.0315810e-09
+ ua1=2.0310005e-09         ub1=-2.7571342e-18        wub1=1.8899129e-25
+ uc1=6.2523140e-11         wuc1=-5.4885400e-18       kt1l=0.00
+ prt=0                     cj=cjp3                   pb=0.8049122
+ mj=0.3954951              cjsw=cjswp3               pbsw=0.8049122
+ mjsw=0.2573111            cjswg=cjswgp3             pbswg=0.8049122
+ mjswg=0.2573111           cgdo=cgop3                cgso=cgop3
+ tcj=0.0009940197          tcjsw=0.0006908749        tcjswg=0.0006908749
+ tpb=0.001625007           tpbsw=0.001625007         tpbswg=0.001625007
+ js=1.900e-07              jsw=1.00e-12              n=1
+ xti=3                     capmod=3                  nqsmod=0
+ xpart=1                   cf=0                      tlev=1
+ tlevc=1                   llc=-0.0165               noimod=2
+ noia=2.0e19               noib=8.0e03               noic=5.4e-12
+ em=3.0e07                 ef=1.094                  minr=1e-60
+ imax=0.01                 imelt=0.01

     14: type=p
+ lmin=1.200e-06-dxlp3-dlmis                          lmax=1.000e-05-dxlp3-dlmis
+ wmin=2.2e-007             wmax=5.0000e-07-dxwp3-dwmis
+ tnom=25.0                 version=3.24              tox=toxp3+toxmis
+ toxm=6.77e-09             xj=1.7000001e-07          nch=4.9500000e17
+ lln=-1                    lwn=1.0000000             wln=1.0000000
+ wwn=1.0000000             lint=3.5000000e-08        ll=0.00
+ lw=0.00                   lwl=0.00                  wint=2.0000000e-08
+ wl=0.00                   ww=0.00                   wwl=0.00
+ mobmod=1                  binunit=2                 xl=-0.02e-6+dxlp3+dlmis
+ xw=0.0+dxwp3+dwmis        dwg=0.00                  dwb=0.00
+ ldif=9.00e-08             hdif=hdifp3               rsh=rshp3
+ rd=0                      rs=0                      vth0=-0.6969150+dvthp3+vthmis
+ lvth0=-5.0894140e-09+dlvthp3                        wvth0=7.2090390e-09+dwvthp3
+ pvth0=-1.1089246e-15+dpvthp3                        k1=0.8422616
+ lk1=1.7858284e-08         wk1=1.1041521e-08         pk1=-1.3236105e-15
+ k2=7.9876470e-02+dk2p3    lk2=-9.1377870e-09+dlk2p3 wk2=-5.1557550e-09
+ pk2=7.2469200e-16         k3=0.00                   dvt0=0.00
+ dvt1=0.00                 dvt2=0.00                 dvt0w=0.00
+ dvt1w=0.00                dvt2w=0.00                nlx=0.00
+ w0=0.00                   k3b=0.00                  vsat=1.5378411e05+dvsatp3
+ wvsat=0+dwvsatp3          lvsat=-3.7500340e-02      ua=4.9978600e-10
+ lua=5.1669870e-17         wua=2.5417124e-18         pua=-2.5188352e-23
+ ub=5.0000000e-20          uc=-1.4113100e-10         luc=1.3801914e-17
+ wuc=-1.7655452e-17        puc=-8.6596870e-24        rdsw=9.0000000e02
+ prwb=0.00                 prwg=0.00                 wr=1.0000000
+ u0=8.0030420e-03+du0p3    lu0=-4.9358130e-10+dlu0p3 wu0=6.1931930e-10+dwu0p3
+ pu0=-1.4965751e-16+dpu0p3 a0=1.0128399              la0=1.9441604e-09
+ wa0=3.4282080e-08         pa0=-2.7097102e-14        keta=1.9746628e-02
+ lketa=-1.2303980e-08      wketa=-7.3130900e-10      pketa=5.4714090e-16
+ a1=0.00                   a2=0.9900000              ags=1.4739780e-02
+ lags=5.2128610e-08        wags=2.6946623e-09        pags=-2.6704059e-14
+ b0=0.00                   b1=0.00                   voff=-0.1071579+dvoffp3
+ lvoff=-5.0809350e-09+dlvoffp3                       wvoff=-2.4467264e-09+dwvoffp3
+ pvoff=2.4692497e-15+dpvoffp3                        nfactor=1.0000000+dnfactorp3
+ pnfactor=0+dpnfactorp3    wnfactor=0+dwnfactorp3    lnfactor=0+dlnfactorp3
+ cit=1.0682475e-03         lcit=-6.5014470e-10       wcit=-2.9820957e-10
+ pcit=3.3753370e-16        cdsc=0.00                 cdscb=0.00
+ cdscd=0.00                eta0=1.0000000e-05+deta0p3
+ peta0=0+dpeta0p3          weta0=0+dweta0p3          leta0=0+dleta0p3
+ etab=-1.0000000e-05       dsub=0.00                 pclm=0.4747727
+ lpclm=2.5000222e-07       pdiblc1=1.0000000e-06     pdiblc2=1.0000000e-05
+ pdiblcb=1.0000000e-02     drout=0.00                pscbe1=1.8738640e08
+ lpscbe1=1.2500110e02      pscbe2=5.0000000e-07      pvag=0.00
+ delta=1.0000000e-02       alpha0=0.00               alpha1=0.143217238
+ beta0=16.10832            kt1=-0.2892435            lkt1=-3.9008510e-09
+ wkt1=2.6791696e-09        pkt1=1.6897048e-15        kt2=-2.7126595e-02
+ lkt2=-3.3475660e-09       wkt2=9.2080900e-10        pkt2=1.5252189e-15
+ at=-5.0000000e04          ute=-0.6418697            lute=2.9824713e-07
+ wute=1.6279429e-08        pute=-1.0155609e-13       ua1=1.9554529e-09
+ lua1=7.4867650e-16        wua1=3.8701010e-17        pua1=-3.8352660e-22
+ ub1=-2.7104761e-18        lub1=-4.6238050e-25       wub1=1.6392816e-25
+ pub1=2.4837533e-31        uc1=6.1648940e-11         luc1=8.6633470e-18
+ wuc1=-7.6656470e-18       puc1=2.1575117e-23        kt1l=0.00
+ prt=0                     cj=cjp3                   pb=0.8049122
+ mj=0.3954951              cjsw=cjswp3               pbsw=0.8049122
+ mjsw=0.2573111            cjswg=cjswgp3             pbswg=0.8049122
+ mjswg=0.2573111           cgdo=cgop3                cgso=cgop3
+ tcj=0.0009940197          tcjsw=0.0006908749        tcjswg=0.0006908749
+ tpb=0.001625007           tpbsw=0.001625007         tpbswg=0.001625007
+ js=1.900e-07              jsw=1.00e-12              n=1
+ xti=3                     capmod=3                  nqsmod=0
+ xpart=1                   cf=0                      tlev=1
+ tlevc=1                   llc=-0.0165               noimod=2
+ noia=2.0e19               noib=8.0e03               noic=5.4e-12
+ em=3.0e07                 ef=1.094                  minr=1e-60
+ imax=0.01                 imelt=0.01

     15: type=p
+ lmin=5.000e-07-dxlp3-dlmis                          lmax=1.200e-06-dxlp3-dlmis
+ wmin=2.2e-007             wmax=5.0000e-07-dxwp3-dwmis
+ tnom=25.0                 version=3.24              tox=toxp3+toxmis
+ toxm=6.77e-09             xj=1.7000001e-07          nch=4.9500000e17
+ lln=-1                    lwn=1.0000000             wln=1.0000000
+ wwn=1.0000000             lint=3.5000000e-08        ll=0.00
+ lw=0.00                   lwl=0.00                  wint=2.0000000e-08
+ wl=0.00                   ww=0.00                   wwl=0.00
+ mobmod=1                  binunit=2                 xl=-0.02e-6+dxlp3+dlmis
+ xw=0.0+dxwp3+dwmis        dwg=0.00                  dwb=0.00
+ ldif=9.00e-08             hdif=hdifp3               rsh=rshp3
+ rd=0                      rs=0                      vth0=-0.6988225+dvthp3+vthmis
+ lvth0=-2.9720428e-09+dlvthp3                        wvth0=5.5172010e-09+dwvthp3
+ pvth0=7.6901610e-16+dpvthp3                         k1=0.8387554
+ lk1=2.1750221e-08         wk1=1.1643079e-08         pk1=-1.9913423e-15
+ k2=7.7793220e-02+dk2p3    lk2=-6.8253770e-09+dlk2p3 wk2=-4.3671790e-09
+ pk2=-1.5062782e-16        k3=0.00                   dvt0=0.00
+ dvt1=0.00                 dvt2=0.00                 dvt0w=0.00
+ dvt1w=0.00                dvt2w=0.00                nlx=0.00
+ w0=0.00                   k3b=0.00                  vsat=1.2585714e05+dvsatp3
+ wvsat=0+dwvsatp3          lvsat=-6.5014080e-03      ua=5.4351430e-10
+ lua=3.1315486e-18         wua=-1.7355058e-17        pua=-3.1029357e-24
+ ub=5.0000000e-20          uc=-1.4399180e-10         luc=1.6977412e-17
+ wuc=-2.5643291e-17        puc=2.0681470e-25         rdsw=9.0000000e02
+ prwb=0.00                 prwg=0.00                 wr=1.0000000
+ u0=7.8093810e-03+du0p3    lu0=-2.7861857e-10+dlu0p3 wu0=3.8132560e-10+dwu0p3
+ pu0=1.1451548e-16+dpu0p3  a0=1.0642401              la0=-5.5110040e-08
+ wa0=-2.2344880e-08        pa0=3.5758840e-14         keta=2.3581030e-02
+ lketa=-1.6560170e-08      wketa=-2.5508482e-09      pketa=2.5668300e-15
+ a1=0.00                   a2=0.9900000              ags=6.6288150e-02
+ lags=-5.0900910e-09       wags=-2.3712159e-08       pags=2.6075162e-15
+ b0=0.00                   b1=0.00                   voff=-0.1186088+dvoffp3
+ lvoff=7.6296080e-09+dlvoffp3                        wvoff=-3.5230960e-10+dwvoffp3
+ pvoff=1.4444692e-16+dpvoffp3                        nfactor=1.0000000+dnfactorp3
+ pnfactor=0+dpnfactorp3    wnfactor=0+dwnfactorp3    lnfactor=0+dlnfactorp3
+ cit=4.5764680e-04         lcit=2.7622016e-11        wcit=1.5922081e-11
+ pcit=-1.1152456e-17       cdsc=0.00                 cdscb=0.00
+ cdscd=0.00                eta0=-4.2714270e-05+deta0p3
+ peta0=0+dpeta0p3          weta0=0+dweta0p3          leta0=5.8512850e-11+dleta0p3
+ etab=4.2714270e-05        letab=-5.8512850e-11      dsub=0.00
+ pclm=0.6980700            lpclm=2.1421234e-09       wpclm=-1.3304762e-08
+ ppclm=1.4768289e-14       pdiblc1=1.0000000e-06     pdiblc2=-5.6985720e-04
+ lpdiblc2=6.4364150e-10    pdiblcb=1.0000000e-02     drout=0.00
+ pscbe1=2.7071427e08       lpscbe1=32.5071400        pscbe2=5.0000000e-07
+ pvag=0.00                 delta=1.0000000e-02       alpha0=0.00
+ alpha1=0.143217238        beta0=16.10832            kt1=-0.2975647
+ lkt1=5.3356430e-09        wkt1=6.7240530e-09        pkt1=-2.8001169e-15
+ kt2=-3.1370852e-02        lkt2=1.3635577e-09        wkt2=1.9651503e-09
+ pkt2=3.6600010e-16        at=-5.0000000e04          ute=-0.3558594
+ lute=-1.9224409e-08       wute=-1.1138885e-07       pute=4.0155710e-14
+ ua1=2.9807412e-09         lua1=-3.8939400e-16       wua1=-4.8652630e-16
+ pua1=1.9947582e-22        ub1=-3.6438770e-18        lub1=5.7369460e-25
+ wub1=5.5249090e-25        pub1=-1.8292942e-31       uc1=5.0477020e-11
+ luc1=2.1064192e-17        wuc1=2.2813721e-17        puc1=-1.2256985e-23
+ kt1l=0.00                 prt=0                     cj=cjp3
+ pb=0.8049122              mj=0.3954951              cjsw=cjswp3
+ pbsw=0.8049122            mjsw=0.2573111            cjswg=cjswgp3
+ pbswg=0.8049122           mjswg=0.2573111           cgdo=cgop3
+ cgso=cgop3                tcj=0.0009940197          tcjsw=0.0006908749
+ tcjswg=0.0006908749       tpb=0.001625007           tpbsw=0.001625007
+ tpbswg=0.001625007        js=1.900e-07              jsw=1.00e-12
+ n=1                       xti=3                     capmod=3
+ nqsmod=0                  xpart=1                   cf=0
+ tlev=1                    tlevc=1                   llc=-0.0165
+ noimod=2                  noia=2.0e19               noib=8.0e03
+ noic=5.4e-12              em=3.0e07                 ef=1.094
+ minr=1e-60                imax=0.01                 imelt=0.01

     16: type=p
+ lmin=3.0e-007             lmax=5.000e-07-dxlp3-dlmis
+ wmin=2.2e-007             wmax=5.0000e-07-dxwp3-dwmis
+ tnom=25.0                 version=3.24              tox=toxp3+toxmis
+ toxm=6.77e-09             xj=1.7000001e-07          nch=4.9500000e17
+ lln=-1                    lwn=1.0000000             wln=1.0000000
+ wwn=1.0000000             lint=3.5000000e-08        ll=0.00
+ lw=0.00                   lwl=0.00                  wint=2.0000000e-08
+ wl=0.00                   ww=0.00                   wwl=0.00
+ mobmod=1                  binunit=2                 xl=-0.02e-6+dxlp3+dlmis
+ xw=0.0+dxwp3+dwmis        dwg=0.00                  dwb=0.00
+ ldif=9.00e-08             hdif=hdifp3               rsh=rshp3
+ rd=0                      rs=0                      vth0=-0.7102714+dvthp3+vthmis
+ lvth0=1.7220052e-09+dlvthp3                         wvth0=-1.3011513e-09+dwvthp3
+ pvth0=3.5645400e-15+dpvthp3                         k1=0.9896178
+ lk1=-4.0103360e-08        wk1=-6.2613200e-08        pk1=2.8453731e-14
+ k2=5.6198710e-02+dk2p3    lk2=2.0283666e-09+dlk2p3  wk2=1.5413164e-08
+ pk2=-8.2605680e-15        k3=0.00                   dvt0=0.00
+ dvt1=0.00                 dvt2=0.00                 dvt0w=0.00
+ dvt1w=0.00                dvt2w=0.00                nlx=0.00
+ w0=0.00                   k3b=0.00                  vsat=1.2733347e05+dvsatp3
+ wvsat=0+dwvsatp3          lvsat=-7.1067050e-03      ua=5.6070820e-10
+ lua=-3.9179540e-18        wua=-3.5812070e-17        pua=4.4644360e-24
+ ub=5.0000000e-20          uc=-2.2165832e-10         luc=4.8820680e-17
+ wuc=6.1397940e-18         puc=-1.2824250e-23        rdsw=9.0000000e02
+ prwb=0.00                 prwg=0.00                 wr=1.0000000
+ u0=7.6553440e-03+du0p3    lu0=-2.1546345e-10+dlu0p3 wu0=2.9765798e-10+dwu0p3
+ pu0=1.4881922e-16+dpu0p3  a0=1.2717079              la0=-1.4017188e-07
+ wa0=1.5110158e-08         pa0=2.0402271e-14         keta=-1.1058724e-02
+ lketa=-2.3578717e-09      wketa=6.0404470e-09       pketa=-9.5560120e-16
+ a1=0.00                   a2=0.9900000              ags=5.1349650e-02
+ lags=1.0346969e-09        wags=-1.6059564e-08       pags=-5.3004870e-16
+ b0=0.00                   b1=0.00                   voff=-0.1000001+dvoffp3
+ pvoff=0+dpvoffp3          wvoff=0+dwvoffp3          lvoff=0+dlvoffp3
+ nfactor=1.0000000+dnfactorp3                        pnfactor=0+dpnfactorp3
+ wnfactor=0+dwnfactorp3    lnfactor=0+dlnfactorp3    cit=5.0953650e-04
+ lcit=6.3472730e-12        wcit=-2.3771051e-11       pcit=5.1217290e-18
+ cdsc=0.00                 cdscb=0.00                cdscd=0.00
+ eta0=-5.9333330e-04+deta0p3                         peta0=0+dpeta0p3
+ weta0=0+dweta0p3          leta0=2.8426667e-10+dleta0p3
+ etab=1.1133335e-03        letab=-4.9746670e-10      dsub=0.00
+ pclm=0.9552779            lpclm=-1.0331307e-07      wpclm=-1.5286366e-07
+ ppclm=7.1987430e-14       pdiblc1=1.0000000e-06     pdiblc2=1.0000000e-03
+ pdiblcb=1.0000000e-02     drout=0.00                pscbe1=3.1533334e08
+ lpscbe1=14.2133340        pscbe2=5.0000000e-07      pvag=0.00
+ delta=1.0000000e-02       alpha0=0.00               alpha1=0.143217238
+ beta0=16.10832            kt1=-0.2914546            lkt1=2.8305438e-09
+ wkt1=-4.2728600e-09       pkt1=1.7086176e-15        kt2=-2.2502899e-02
+ lkt2=-2.2723026e-09       wkt2=5.9977000e-09        pkt2=-1.2873453e-15
+ at=-5.0000000e04          ute=-0.4071587            lute=1.8082899e-09
+ wute=-8.5249080e-09       pute=-2.0185026e-15       ua1=2.0309998e-09
+ ub1=-2.3083980e-18        lub1=2.6148351e-26        wub1=3.9016210e-26
+ pub1=2.7595218e-32        uc1=1.0124479e-10         luc1=2.4940948e-19
+ wuc1=-1.9569818e-17       puc1=5.1202650e-24        kt1l=0.00
+ prt=0                     cj=cjp3                   pb=0.8049122
+ mj=0.3954951              cjsw=cjswp3               pbsw=0.8049122
+ mjsw=0.2573111            cjswg=cjswgp3             pbswg=0.8049122
+ mjswg=0.2573111           cgdo=cgop3                cgso=cgop3
+ tcj=0.0009940197          tcjsw=0.0006908749        tcjswg=0.0006908749
+ tpb=0.001625007           tpbsw=0.001625007         tpbswg=0.001625007
+ js=1.900e-07              jsw=1.00e-12              n=1
+ xti=3                     capmod=3                  nqsmod=0
+ xpart=1                   cf=0                      tlev=1
+ tlevc=1                   llc=-0.0165               noimod=2
+ noia=2.0e19               noib=8.0e03               noic=5.4e-12
+ em=3.0e07                 ef=1.094                  minr=1e-60
+ imax=0.01                 imelt=0.01

     }
ends pch3_mis

endsection mos_3v

//  *************************************************************
//                                                              *
//               1.8V native NMOS DEVICE MODEL                  *
//                                                              *
//  *************************************************************
//
section mosna

model nanch bsim3v3  {
 1: type=n
+ lmin=8.2e-07 - dxlna lmax=2.1e-05 wmin=2.2e-07
+ wmax=0.000101 noimod=2 em=4.1e07
+ ef=0.95 noia=2.0e20 noib=1.0e04
+ noic=5.0e-13 tnom=25 version=3.24
+ tox=toxna toxm=toxna xj=2e-07
+ nch=1.052e+15 lln=-1 lwn=1
+ wln=1 wwn=1 lint=2.675e-08
+ ll=0 lw=0 lwl=0
+ wint=2.6e-08 wl=0 ww=0
+ wwl=0 mobmod=1 binunit=2
+ xl= - 2e-08 + dxlna xw=0 + dxwna dwg=0
+ dwb=0 ldif=9e-08
+ hdif=hdifna rsh=6.8 rd=0
+ rs=0 vth0= - 0.01774261 + dvthna
+ lvth0=6.182923e-08 wvth0=-3.753495e-09 pvth0=-5.377128e-15
+ k1=0.11953682 lk1=-3.977839e-09 wk1=8.240465e-09
+ pk1=-1.371659e-15 k2=-0.0449140425 lk2=-8.184622e-10
+ wk2=-4.367525e-10 pk2=1.205304e-16 k3=0
+ dvt0=0 dvt1=0 dvt2=0
+ dvt0w=0 dvt1w=0 dvt2w=0
+ nlx=0 w0=0 k3b=0
+ vsat=97603.5 lvsat=0.01646395 wvsat=0.003378191
+ pvsat=5.871035e-11 ua=9.102442e-11 lua=2.508072e-19
+ wua=-1.036519e-17 pua=-2.537652e-24 ub=2.023123e-18
+ lub=7.463114e-25 wub=-1.589492e-26 pub=-1.60874e-31
+ uc=-2.064959e-11 luc=6.691113e-18 wuc=-1.462443e-17
+ puc=5.745368e-24 rdsw=68 prwb=0
+ prwg=0 wr=1 u0=0.0544471
+ lu0=9.232913e-10 wu0=2.605018e-09 pu0=-1.181193e-15
+ a0=1.318223 la0=-3.152826e-07 wa0=-2.414332e-07
+ pa0=2.113845e-13 keta=-0.007562 a1=0
+ a2=0.99 ags=0.01817691 lags=1.359381e-09
+ wags=1.844599e-08 pags=-1.375421e-14 b0=0
+ b1=0 voff=-0.1437579 lvoff=-1.670469e-08
+ wvoff=4.828936e-10 pvoff=5.80468e-15 nfactor=1
+ cit=0.0002597791 lcit=4.032749e-10 cdsc=0
+ cdscb=0 cdscd=0 eta0=0.003399928
+ leta0=8.502075e-10 weta0=1.186005e-09 peta0=-1.969099e-16
+ etab=0.001011681 letab=-4.725199e-10 wetab=4.574829e-10
+ petab=-1.154549e-16 dsub=0 pclm=0.4528076
+ lpclm=2.005277e-07 wpclm=2.740156e-07 ppclm=1.122796e-14
+ pdiblc1=0.03034016 lpdiblc1=-2.539301e-10 wpdiblc1=-3.441731e-09
+ ppdiblc1=2.569253e-15 pdiblc2=0.00225 pdiblcb=0.1804105
+ lpdiblcb=-5.115617e-10 wpdiblcb=2.114142e-08 ppdiblcb=5.175938e-15
+ drout=0 pscbe1=3.030791e+08 lpscbe1=-0.7799484
+ wpscbe1=-0.03412339 ppscbe1=2.05864e-07 pscbe2=1.5243e-07
+ pvag=0 delta=0.003 alpha1=1.876e-2
+ beta0=8.1 kt1=-0.322786 lkt1=3.214286e-08
+ wkt1=-4.367528e-09 pkt1=1.205308e-15 kt2=-0.002
+ at=10000 ute=-1.570186 lute=1.603067e-07
+ wute=4.146074e-08 pute=1.015063e-14 ua1=4e-09
+ ub1=-6e-18 uc1=-2.8e-12 kt1l=0
+ prt=0 cj=cjna pb=0.5667062
+ mj=0.3904209 cjsw=cjswna pbsw=0.5667062
+ mjsw=0.0428681 cjswg=cjswgna pbswg=0.5667062
+ mjswg=0.4305378 cgdo=cgona cgso=cgona
+ tcj=0.001812677 tcjsw=0.001103346 tcjswg=0.001103346
+ tpb=0.001711098 tpbsw=0.001711098 tpbswg=0.001711098
+ js=8.50e-7 jsw=2.50e-12 n=1
+ xti=3 capmod=3 nqsmod=0
+ xpart=1 cf=0 tlev=1
+ tlevc=1
+ alpha0=0 llc=-0.03
+ minr=1e-60 imax=0.01 imelt=0.01

 2: type=n
+ lmin=5e-07 lmax=8.2e-07 - dxlna wmin=2.2e-07
+ wmax=0.000101 noimod=2 em=4.1e07
+ ef=0.95 noia=2.0e20 noib=1.0e04
+ noic=5.0e-13 tnom=25 version=3.24
+ tox=toxna toxm=toxna xj=2e-07
+ nch=1.052e+15 lln=-1 lwn=1
+ wln=1 wwn=1 lint=2.675e-08
+ ll=0 lw=0 lwl=0
+ wint=2.6e-08 wl=0 ww=0
+ wwl=0 mobmod=1 binunit=2
+ xl= - 2e-08 + dxlna xw=0 + dxwna dwg=0
+ dwb=0 ldif=9e-08
+ hdif=hdifna rsh=6.8 rd=0
+ rs=0 vth0=0.02792398 + dvthna
+ lvth0=2.773913e-08 wvth0=-1.438199e-08 pvth0=2.557044e-15
+ k1=0.11404253 lk1=1.23647e-10 wk1=8.078899e-09
+ pk1=-1.25105e-15 k2=-0.0444382913 lk2=-1.17361e-09
+ wk2=-6.966282e-10 pk2=3.145276e-16 k3=0
+ dvt0=0 dvt1=0 dvt2=0
+ dvt0w=0 dvt1w=0 dvt2w=0
+ nlx=0 w0=0 k3b=0
+ vsat=154073 lvsat=-0.02569051 wvsat=0.00243878
+ pvsat=7.599806e-10 ua=9.171293e-11 lua=-2.631544e-19
+ wua=-1.733133e-17 pua=2.662571e-24 ub=2.770609e-18
+ lub=1.88313e-25 wub=-1.480558e-25 pub=-6.221591e-32
+ uc=-2.834392e-11 luc=1.243493e-17 wuc=-6.156361e-18
+ puc=-5.760438e-25 rdsw=68 prwb=0
+ prwg=0 wr=1 u0=0.05722036
+ lu0=-1.146955e-09 wu0=9.626542e-10 pu0=4.483137e-17
+ a0=0.6052103 la0=2.169814e-07 wa0=-1.144547e-07
+ pa0=1.165951e-13 keta=-0.007562 a1=0
+ a2=0.99 ags=0.01999473 lags=2.377243e-12
+ wags=5.327309e-11 pags=-2.40528e-17 b0=0
+ b1=0 voff=-0.1601644 lvoff=-4.457263e-09
+ wvoff=2.527387e-08 pvoff=-1.270178e-14 nfactor=1
+ cit=0.001565254 lcit=-5.712622e-10 cdsc=0
+ cdscb=0 cdscd=0 eta0=-0.002726106
+ leta0=5.423292e-09 weta0=-2.225066e-09 peta0=2.349455e-15
+ etab=0.0003545133 letab=1.805535e-11 wetab=5.475407e-10
+ petab=-1.826831e-16 dsub=0 pclm=1.5367825
+ lpclm=-6.086595e-07 wpclm=5.564588e-07 ppclm=-1.996159e-13
+ pdiblc1=0.01805861 lpdiblc1=8.914247e-09 wpdiblc1=-3.062515e-09
+ ppdiblc1=2.286167e-15 pdiblc2=0.00225 pdiblcb=0.1798815
+ lpdiblcb=-1.166351e-10 wpdiblcb=2.649413e-08 ppdiblcb=1.180139e-15
+ drout=0 pscbe1=3.005564e+08 lpscbe1=1.103308
+ wpscbe1=0.6114948 ppscbe1=-2.760899e-07 pscbe2=1.5243e-07
+ pvag=0 delta=0.003 alpha1=1.876e-2
+ beta0=8.1 kt1=-0.3252268 lkt1=3.396488e-08
+ wkt1=-6.966276e-09 pkt1=3.145274e-15 kt2=-0.002
+ at=10000 ute=-1.327971 lute=-2.05067e-08
+ wute=8.682543e-08 pute=-2.371411e-14 ua1=4e-09
+ ub1=-6e-18 uc1=-2.8e-12 kt1l=0
+ prt=0 cj=cjna pb=0.5667062
+ mj=0.3904209 cjsw=cjswna pbsw=0.5667062
+ mjsw=0.0428681 cjswg=cjswgna pbswg=0.5667062
+ mjswg=0.4305378 cgdo=cgona cgso=cgona
+ tcj=0.001812677 tcjsw=0.001103346 tcjswg=0.001103346
+ tpb=0.001711098 tpbsw=0.001711098 tpbswg=0.001711098
+ js=8.50e-7 jsw=2.50e-12 n=1
+ xti=3 capmod=3 nqsmod=0
+ xpart=1 cf=0 tlev=1
+ tlevc=1
+ alpha0=0 llc=-0.03
+ minr=1e-60 imax=0.01 imelt=0.01

     }
endsection mosna

//  *************************************************************
//                                                              *
//               3.3V native NMOS DEVICE MODEL                  *
//                                                              *
//  *************************************************************
//
section mosna3

model nanch3 bsim3v3  {
 1: type=n
+ lmin=1.52e-06 - dxlna3 lmax=2.1e-05 wmin=2.2e-07
+ wmax=1.01e-04 noimod=2 em=4.1e07
+ ef=1.01 noia=1.0e20 noib=2.0e04
+ noic=2.0e-13 tnom=25 version=3.24
+ tox=toxna3 toxm=toxna3 xj=1.7e-07
+ nch=5.8e+15 lln=-1 lwn=1
+ wln=1 wwn=1 lint=1.1e-07
+ ll=0 lw=0 lwl=0
+ wint=1.64e-08 wl=0 ww=0
+ wwl=0 mobmod=1 binunit=2
+ xl= - 2e-8 + dxlna3 xw=0 + dxwna3 dwg=0
+ dwb=0 ldif=9e-08
+ hdif=hdifna3 rsh=6.8 rd=0
+ rs=0 vth0= - 0.09478436 + dvthna3
+ lvth0=-3.815484e-08 wvth0=-1.353864e-08 pvth0=-9.114775e-16
+ k1=0.07518722 lk1=-2.494324e-08 wk1=3.240441e-08
+ pk1=1.425852e-14 k2=-0.002 k3=0
+ dvt0=0 dvt1=0 dvt2=0
+ dvt0w=0 dvt1w=0 dvt2w=0
+ nlx=0 w0=0 k3b=0
+ vsat=103854 lvsat=-3.55722e-05 wvsat=0.001478785
+ pvsat=3.602473e-10 ua=4.923768e-11 lua=4.496429e-16
+ wua=6.08351e-17 pua=-8.462483e-23 ub=2.081755e-18
+ lub=7.512439e-25 wub=-1.655545e-25 pub=-1.596647e-31
+ uc=3.085943e-13 luc=-1.032446e-19 wuc=-5.505085e-18
+ puc=1.045582e-24 rdsw=220 prwb=0
+ prwg=0 wr=1 u0=0.05171998
+ lu0=5.906318e-11 wu0=8.10373e-10 pu0=-5.98144e-16
+ a0=1 keta=-0.01830086 lketa=4.266525e-11
+ wketa=-1.773655e-09 pketa=-4.320807e-16 a1=0
+ a2=1 ags=0.79888 lags=-4.465664e-07
+ wags=-4.177232e-08 pags=5.346858e-14 b0=0
+ b1=0 voff=-0.1081457 lvoff=2.321209e-09
+ wvoff=1.475376e-09 pvoff=-2.350736e-14 nfactor=1
+ cit=0.000162 cdsc=0 cdscb=0
+ cdscd=0 eta0=0.00172966 leta0=8.846976e-09
+ weta0=-2.508041e-10 peta0=-2.15119e-16 etab=0.0009718285
+ letab=3.797812e-10 wetab=-9.240519e-11 petab=-1.219557e-16
+ dsub=0 pclm=0.5239226 lpclm=2.677888e-06
+ wpclm=-9.599169e-08 ppclm=1.394485e-12 pdiblc1=9.767e-07
+ pdiblc2=0.001081524 lpdiblc2=1.821685e-10 wpdiblc2=-2.440943e-11
+ ppdiblc2=2.406769e-16 pdiblcb=0 drout=0
+ pscbe1=5.76e+08 pscbe2=1e-06 pvag=8
+ delta=0.002 alpha1=1.771e-03 beta0=7.2
+ kt1=-0.2806568 lkt1=-1.599956e-10 wkt1=6.651208e-09
+ pkt1=1.620303e-15 kt2=-0.013 at=10000
+ ute=-1.904673 lute=1.879744e-07 wute=5.345823e-08
+ pute=3.291194e-14 ua1=8.047672e-10 lua1=-2.766493e-18
+ wua1=-4.82784e-17 pua1=2.801685e-23 ub1=-2.512189e-18
+ lub1=-5.333165e-28 wub1=2.217068e-26 pub1=5.401006e-33
+ uc1=-1.3e-11 kt1l=0 prt=0
+ cj=cjna3 pb=0.5947797 mj=0.4342894
+ cjsw=cjswna3 pbsw=0.5947797 mjsw=0.0158148
+ cjswg=cjswgna3 pbswg=0.5947797 mjswg=0.541221
+ cgdo=cgona3 cgso=cgona3 tcj=0.0046087
+ tcjsw=0.007157987 tcjswg=0.007157987 tpb=0.002492415
+ tpbsw=0.002492415 tpbswg=0.002492415 js=9.80e-7
+ jsw=3.0e-12 n=1 xti=3
+ capmod=3 nqsmod=0 xpart=1
+ cf=0 tlev=1 tlevc=1
+ alpha0=0
+ llc=-0.0135
+ minr=1e-60 imax=0.01 imelt=0.01

 2: type=n
+ lmin=1.2e-06 lmax=1.52e-06 - dxlna3 wmin=2.2e-07
+ wmax=1.01e-04 noimod=2 em=4.1e07
+ ef=1.01 noia=1.0e20 noib=2.0e04
+ noic=2.0e-13 tnom=25 version=3.24
+ tox=toxna3 toxm=toxna3 xj=1.7e-07
+ nch=5.8e+15 lln=-1 lwn=1
+ wln=1 wwn=1 lint=1.1e-07
+ ll=0 lw=0 lwl=0
+ wint=1.64e-08 wl=0 ww=0
+ wwl=0 mobmod=1 binunit=2
+ xl= - 2e-8 + dxlna3 xw=0 + dxwna3 dwg=0
+ dwb=0 ldif=9e-08
+ hdif=hdifna3 rsh=6.8 rd=0
+ rs=0 vth0= - 0.05361792 + dvthna3
+ lvth0=-9.084788e-08 wvth0=-5.219657e-09 pvth0=-1.155977e-14
+ k1=0.0548448 lk1=1.095044e-09 wk1=5.220765e-08
+ pk1=-1.108962e-14 k2=-0.002 k3=0
+ dvt0=0 dvt1=0 dvt2=0
+ dvt0w=0 dvt1w=0 dvt2w=0
+ nlx=0 w0=0 k3b=0
+ vsat=118376.8 lvsat=-0.01862484 wvsat=-0.002351273
+ pvsat=5.262721e-09 ua=3.333493e-10 lua=8.597997e-17
+ wua=1.334063e-17 pua=-2.383191e-23 ub=2.656073e-18
+ lub=1.611759e-26 wub=-1.627728e-25 pub=-1.632252e-31
+ uc=-9.803229e-14 luc=4.17237e-19 wuc=-1.387119e-18
+ puc=-4.225415e-24 rdsw=220 prwb=0
+ prwg=0 wr=1 u0=0.05668826
+ lu0=-6.300333e-09 wu0=1.190146e-10 pu0=2.867948e-16
+ a0=-9.648092 la0=1.362956e-05 wa0=1.972317e-06
+ pa0=-2.524565e-12 keta=-0.03065319 lketa=1.585364e-08
+ wketa=-9.007868e-09 pketa=8.827711e-15 a1=0
+ a2=1 ags=0.6133333 lags=-2.090666e-07
+ b0=0 b1=0 voff=-0.103894
+ lvoff=-3.1209e-09 wvoff=-4.158169e-08 pvoff=3.160569e-14
+ nfactor=1 cit=0.000162 cdsc=0
+ cdscb=0 cdscd=0 eta0=-0.0006868758
+ leta0=1.194014e-08 weta0=-1.888288e-09 peta0=1.88086e-15
+ etab=-4.851932e-05 letab=1.685826e-09 wetab=-8.2514e-11
+ petab=-1.346164e-16 dsub=0 pclm=-0.7794965
+ lpclm=4.346263e-06 wpclm=2.298267e-06 ppclm=-1.670166e-12
+ pdiblc1=9.767e-07 pdiblc2=0.001225951 lpdiblc2=-2.697764e-12
+ wpdiblc2=1.422751e-10 ppdiblc2=2.732071e-17 pdiblcb=0
+ drout=0 pscbe1=5.76e+08 pscbe2=1e-06
+ pvag=8 delta=0.002 alpha1=1.771e-3
+ beta0=7.2 kt1=-0.2833356 lkt1=3.268843e-09
+ wkt1=3.377951e-08 pkt1=-3.310392e-14 kt2=-0.013
+ at=10000 ute=-1.677388 lute=-1.029496e-07
+ wute=2.571094e-07 pute=-2.277616e-13 ua1=1.137785e-09
+ lua1=-4.290296e-16 wua1=-1.125984e-16 pua1=1.103464e-22
+ ub1=-2.521118e-18 lub1=1.089613e-26 wub1=1.125983e-25
+ pub1=-1.103463e-31 uc1=-1.3e-11 kt1l=0
+ prt=0 cj=cjna3 pb=0.5947797
+ mj=0.4342894 cjsw=cjswna3 pbsw=0.5947797
+ mjsw=0.0158148 cjswg=cjswgna3 pbswg=0.5947797
+ mjswg=0.541221 cgdo=cgona3 cgso=cgona3
+ tcj=0.0046087 tcjsw=0.007157987 tcjswg=0.007157987
+ tpb=0.002492415 tpbsw=0.002492415 tpbswg=0.002492415
+ js=9.80e-07 jsw=3.0e-12 n=1
+ xti=3 capmod=3 nqsmod=0
+ xpart=1 cf=0 tlev=1
+ tlevc=1
+ alpha0=0 llc=-0.0135
+ minr=1e-60 imax=0.01 imelt=0.01

     }
endsection mosna3

//  *************************************************************
//                                                              *
//                                                              *
//        1.8V MEDIUM VT NMOS DEVICE MODEL                      *
//                                                              *
//                                                              *
//  *************************************************************
section mosm
model mench bsim3v3 type=n
+ lmin=3e-07 lmax=1.01e-05 wmin=2.2e-07
+ wmax=1.01e-04 noimod=2 em=4.1e07
+ ef=1.01 noia=5.0e19 noib=3.0e04
+ noic=1.0e-13 tnom=25 version=3.24
+ tox=toxnm toxm=toxnm xj=1.6e-07
+ nch=4.05e+17 lln=-1 lwn=1
+ wln=1 wwn=1 lint=5e-10
+ ll=0 lw=0 lwl=0
+ wint=0 wl=0 ww=0
+ wwl=0 mobmod=1 binunit=2
+ xl= - 2e-8 + dxlm xw=0 + dxwm dwg=0
+ dwb=0 ldif=9e-08
+ hdif=hdifnm rsh=6.8 rd=0
+ rs=0 rsc=0 rdc=0
+ vth0=0.269 + dvtnm lvth0=5.606527e-10 wvth0=-9.253716e-09
+ pvth0=1.664968e-15 k1=0.5591156 lk1=1.111048e-10
+ wk1=-1.675618e-08 pk1=3.665751e-15 k2=-0.01496823
+ lk2=-1.279178e-08 wk2=1.528422e-09 pk2=-2.542514e-15
+ k3=0 dvt0=0 dvt1=0
+ dvt2=0 dvt0w=0 dvt1w=0
+ dvt2w=0 nlx=0 w0=0
+ k3b=0 vsat=81119.9 lvsat=4.76535e-07
+ wvsat=3.15432e-04 pvsat=-6.855e-12 ua=-1.319004e-09
+ lua=-6.366478e-17 wua=2.674692e-16 pua=-1.129892e-22
+ ub=3.288295e-18 lub=-4.317856e-26 wub=-3.546532e-25
+ pub=9.313476e-32 uc=1.938676e-10 luc=-2.553199e-17
+ wuc=-2.389209e-17 puc=-2.274778e-25 rdsw=153
+ prwb=0 prwg=0 wr=1
+ u0=0.03681366 lu0=1.945608e-09 wu0=3.41269e-10
+ pu0=-5.811061e-16 a0=1.781642 la0=7.125971e-08
+ wa0=1.184309e-07 pa0=-3.307579e-14 keta=-0.06342262
+ lketa=2.62917e-08 wketa=9.182592e-09 pketa=-6.998226e-15
+ a1=0 a2=0.99 ags=0.5686571
+ lags=-1.926098e-07 wags=-2.718157e-09 pags=5.692214e-14
+ b0=0 b1=0 voff=-0.1101922
+ lvoff=1.699486e-08 wvoff=4.966385e-10 pvoff=-5.05031e-15
+ nfactor=1.319369 cit=0.0003136176 lcit=1.261591e-13
+ pcit=-3.653581e-21 cdsc=0 cdscb=0
+ cdscd=0 eta0=3.832765e-06 leta0=1.085421e-09
+ weta0=7.437697e-11 peta0=-6.272344e-18 etab=7.034518e-05
+ letab=-3.9168e-10 wetab=-3.338162e-10 petab=1.103976e-16
+ dsub=0 pclm=1.488967 lpclm=9.620652e-08
+ wpclm=1.017124e-08 ppclm=5.87865e-14 pdiblc1=0
+ pdiblc2=5.977472e-05 lpdiblc2=-5.25458e-14 wpdiblc2=-2.787908e-12
+ ppdiblc2=5.331805e-19 pdiblcb=0 drout=0
+ pscbe1=2.847373e+08 lpscbe1=152.3207 wpscbe1=6.476262
+ ppscbe1=-3.657594e-05 pscbe2=4.322527e-06 lpscbe2=-1.143884e-12
+ wpscbe2=-1.332426e-13 ppscbe2=4.172743e-20 pvag=0
+ delta=0.01007309 ldelta=-2.185477e-11 wdelta=-7.416717e-10
+ pdelta=2.217599e-16 alpha0=0 alpha1=4.3
+ beta0=15.7 kt1=-0.2501805 lkt1=-3.924464e-09
+ wkt1=5.371344e-09 pkt1=3.937948e-15 kt2=0.0001368415
+ lkt2=2.816631e-10 wkt2=2.349817e-10 pkt2=-2.858033e-15
+ at=1.85261e+04 lat=6.89368e-08 wat=-4.56312e-05
+ pat=-9.91712e-13 ute=-1.739923 lute=2.450424e-07
+ wute=1.676158e-07 pute=-7.145826e-14 ua1=2.609226e-09
+ lua1=5.698608e-16 wua1=3.799863e-16 pua1=-2.629768e-22
+ ub1=-4.137546e-18 lub1=-4.433101e-26 wub1=-1.979899e-25
+ pub1=1.395532e-31 uc1=-1.005754e-10 luc1=5.85099e-18
+ wuc1=1.726128e-19 puc1=-1.755297e-24 kt1l=0
+ prt=0 cj=cjnm pb=0.692279
+ mj=0.3156655 cjsw=cjswnm pbsw=0.692279
+ mjsw=0.3388699 cjswg=cjswgnm pbswg=0.692279
+ mjswg=0.63895 tcj=9.812649e-4 tcjsw=8.209058e-4
+ tcjswg=8.209058e-4 tpb=1.730634e-3 tpbsw=1.730634e-3
+ tpbswg=1.730634e-3 js=2e-06 jsw=2.2e-11
+ n=1 xti=3 cgdo=cgonm
+ cgso=cgonm capmod=3 nqsmod=0
+ xpart=1 cf=0 tlev=1
+ tlevc=1
+ llc=-0.0285
+ minr=1e-60 imax=0.01 imelt=0.01
//
//  *************************************************************
//                                                              *
//       1.8V MEDIUM VT PMOS DEVICES MODEL                      *
//                                                              *
//  *************************************************************
//
model mepch bsim3v3 type=p
+ lmin=2.5e-07 lmax=1.01e-05 wmin=2.2e-07
+ wmax=1.01e-04 noimod=2 em=2.1e07
+ ef=0.99 noia=7.0e18 noib=8.0e04
+ noic=1.4e-12 tnom=25 version=3.24
+ tox=toxpm toxm=toxpm xj=1.8e-07
+ nch=1.36e+17 lln=-1 lwn=1
+ wln=1 wwn=1 lint=1e-08
+ ll=0 lw=0 lwl=0
+ wint=1e-09 wl=0 ww=0
+ wwl=0 mobmod=1 binunit=2
+ xl= - 2e-8 + dxlm xw=0 + dxwm dwg=0
+ dwb=0 ldif=9e-08
+ rsh=7.2 rd=0 rs=0
+ vth0= - 0.1277685 + dvtpm lvth0=-2.741743e-08
+ wvth0=-4.339415e-09 pvth0=-1.491672e-15 k1=0.359678
+ lk1=1.812663e-08 wk1=4.333335e-09 pk1=-9.685281e-16
+ k2=-0.02308364 lk2=-5.411252e-09 wk2=-8.254332e-10
+ pk2=-2.549191e-16 k3=0 dvt0=0
+ dvt1=0 dvt2=0 dvt0w=0
+ dvt1w=0 dvt2w=0 nlx=0
+ w0=0 k3b=0 vsat=6.1316810e+04
+ lvsat=-3.3127780e-05 wvsat=-1.6997411e-03 pvsat=3.3710970e-10
+ ua=5.789614e-10 lua=-1.222705e-16 wua=-1.753907e-16
+ pua=7.452231e-23 ub=1.539438e-18 lub=4.480006e-26
+ wub=-1.0584e-26 pub=-7.741567e-32 uc=1.404274e-11
+ luc=-6.795524e-18 wuc=-5.952304e-18 puc=-3.757301e-24
+ rdsw=561 prwb=0 prwg=0
+ wr=1 u0=1.2047960e-02 lu0=-2.0174651e-10
+ wu0=-2.9466538e-10 pu0=8.5541960e-17 a0=1.525474
+ la0=-1.208591e-07 wa0=-1.408271e-07 pa0=3.239023e-14
+ keta=-0.0174752 lketa=-7.225252e-09 wketa=1.444242e-09
+ pketa=2.442963e-15 a1=0 a2=1
+ ags=0.3815645 lags=1.06224e-06 wags=-6.455503e-08
+ pags=1.484767e-14 b0=0 b1=0
+ voff=-0.09474722 lvoff=-3.948091e-09 wvoff=-5.054649e-09
+ pvoff=-1.447926e-15 nfactor=1.251922 lnfactor=6.053815e-08
+ wnfactor=-6.715685e-08 pnfactor=-1.986104e-14 cit=0.00015
+ cdsc=0 cdscb=0 cdscd=0
+ eta0=0.001744574 leta0=6.286667e-10 weta0=-7.279339e-11
+ peta0=6.829087e-17 etab=2.953351e-05 letab=-4.01464e-10
+ wetab=1.089399e-11 petab=-1.105209e-16 dsub=0
+ pclm=1.795303 lpclm=1.063205e-07 wpclm=1.921448e-07
+ ppclm=-6.184687e-14 pdiblc1=0 pdiblc2=4.997453e-05
+ lpdiblc2=-1.487093e-14 wpdiblc2=6.652175e-15 ppdiblc2=4.436149e-21
+ pdiblcb=0 drout=0 pscbe1=3e+08
+ pscbe2=1.60061e-07 lpscbe2=-6.196025e-16 wpscbe2=-6.192976e-16
+ ppscbe2=6.285877e-21 pvag=0.004369789 lpvag=-1.005052e-09
+ wpvag=-1.171104e-09 ppvag=2.693538e-16 delta=0.004925875
+ ldelta=7.523679e-10 wdelta=-1.245712e-11 pdelta=1.2644e-16
+ alpha0=0 alpha1=0.62 beta0=17.9
+ kt1=-0.2269661 lkt1=-1.440582e-08 wkt1=-1.676007e-08
+ pkt1=3.854973e-15 kt2=-0.02984493 lkt2=1.332793e-11
+ wkt2=-1.573173e-09 pkt2=-1.352118e-16 at=7.1258e+04
+ lat=1.1650e-05 wat=-5.0284e-03 pat=-9.8637e-11
+ ute=-2.083674 lute=1.851138e-07 wute=1.63401e-07
+ pute=-6.900854e-14 ua1=-2.793282e-09 lua1=1.062134e-15
+ wua1=9.353043e-16 pua1=-3.66072e-22 ub1=8.811349e-19
+ lub1=-6.945912e-25 wub1=-8.973625e-25 pub1=1.803226e-31
+ uc1=-8.829209e-12 luc1=1.435134e-18 wuc1=-2.431682e-17
+ puc1=-1.571694e-24 kt1l=0 prt=0
+ cj=cjpm mj=0.4490538 pb=0.93893
+ cjsw=cjswpm mjsw=0.2931001 pbsw=0.93893
+ cjswg=cjswgpm mjswg=0.6881348 pbswg=0.93893
+ tcj=8.452656e-4 tcjsw=5.958483e-4 tcjswg=5.958483e-4
+ tpb=1.661621e-3 tpbsw=1.661621e-3 tpbswg=1.661621e-3
+ cgdo=cgopm cgso=cgopm js=4e-7
+ jsw=7.0029e-11 capmod=3 xti=3
+ n=1 nqsmod=0 xpart=1
+ cf=0 tlev=1 tlevc=1
+ hdif=hdifpm
+ llc=-0.028
+ minr=1e-60 imax=0.01 imelt=0.01
endsection mosm
//
//  *************************************************************
//                                                              *
//                                                              *
//        3.3V MEDIUM VT NMOS DEVICE MODEL                      *
//                                                              *
//                                                              *
//  *************************************************************
//
//
section mos3m
model mench3 bsim3v3 type=n
+ lmin=6.0e-07 lmax=1.01e-05 wmin=2.2e-07
+ wmax=1.01e-04 noimod=2 em=4.1e07
+ ef=0.996 noia=5.0e20 noib=3.0e04
+ noic=1.0e-13 tnom=25 version=3.24
+ tox=toxn3m toxm=toxn3m xj=1.6e-07
+ nch=3.59e+17 lln=-1 lwn=1
+ wln=1 wwn=1 lint=7.5e-08
+ ll=0 lw=0 lwl=0
+ wint=5e-09 wl=0 ww=0
+ wwl=0 mobmod=1 binunit=2
+ xl= - 2e-8 + dxl3m xw=0 + dxw3m dwg=0
+ dwb=0 ldif=9e-08
+ rsh=6.8 rd=0 rs=0
+ vth0=0.4270704 + dvtn3m lvth0=1.3368909e-08 wvth0=1.0802962e-08
+ pvth0=-1.2265666e-14 k1=0.9362023 lk1=3.075932e-08
+ wk1=1.349711e-09 pk1=-1.356316e-14 k2=-0.02543646
+ lk2=-3.211724e-08 wk2=-5.281537e-09 pk2=5.85489e-15
+ k3=0 dvt0=0 dvt1=0
+ dvt2=0 dvt0w=0 dvt1w=0
+ dvt2w=0 nlx=0 w0=0
+ k3b=0 vsat=5.5007480e+04 lvsat=1.0967914e-02
+ wvsat=4.9011050e-03 pvsat=-2.7160376e-09 ua=-9.7866690e-10
+ lua=-2.2860644e-16 wua=2.1106961e-17 pua=-5.1234610e-23
+ ub=2.9868197e-18 lub=1.4529398e-25 wub=-1.0580369e-25
+ pub=-1.0054509e-31 uc=1.3799423e-10 luc=-5.7929880e-18
+ wuc=-1.3411668e-17 puc=-9.8556380e-24 rdsw=524
+ prwb=0 prwg=0 wr=1
+ u0=3.8011500e-02 lu0=2.6883984e-09 wu0=7.5124530e-11
+ pu0=-7.5275150e-16 a0=1.3772298 la0=-1.9211895e-07
+ wa0=-9.1577730e-08 pa0=9.9323010e-14 keta=-3.7988340e-02
+ lketa=1.0161284e-08 wketa=-1.2142373e-10 pketa=-2.7449274e-15
+ a1=0 a2=1 ags=0.2878821
+ lags=-2.5206168e-08 wags=-1.4408995e-08 pags=2.6478284e-14
+ b0=0 b1=0 voff=-0.08273634
+ lvoff=1.45809e-08 wvoff=-1.084385e-08 pvoff=5.065768e-15
+ nfactor=0.8476041 lnfactor=8.793047e-08 wnfactor=1.920809e-07
+ pnfactor=-9.574974e-14 cit=0.0001 cdsc=0
+ cdscb=0 cdscd=0 eta0=1.2e-05
+ etab=6.624219e-06 letab=-1.669141e-10 wetab=4.419653e-12
+ petab=-4.445723e-17 dsub=0 pclm=1.00036
+ lpclm=-3.607289e-09 wpclm=-1.497573e-08 ppclm=1.500568e-13
+ pdiblc1=0 pdiblc2=0.001447742 lpdiblc2=7.477907e-10
+ wpdiblc2=-1.591014e-10 ppdiblc2=3.375206e-16 pdiblcb=0
+ drout=0 pscbe1=3.014856e+08 lpscbe1=102.7385
+ wpscbe1=1.073662 ppscbe1=-1.075807e-05 pscbe2=1.160473e-05
+ lpscbe2=-2.05579e-12 wpscbe2=3.246036e-14 ppscbe2=-3.252531e-19
+ pvag=0 delta=0.01 alpha0=0
+ alpha1=4.42 beta0=22.7 kt1=-0.2621017
+ lkt1=1.693316e-11 pkt1=-4.741286e-18 kt2=-0.0218
+ at=62616.94 lat=-0.02622174 wat=-0.0001876884
+ pat=1.880638e-09 ute=-2.114691 lute=1.896769e-07
+ wute=-5.150003e-08 pute=-1.605202e-14 ua1=3.812941e-10
+ lua1=4.98081e-16 wua1=-8.176987e-17 pua1=-9.50982e-23
+ ub1=-1.832376e-18 lub1=-7.673399e-27 wub1=-1.965718e-25
+ pub1=2.574076e-31 uc1=-7.219594e-11 luc1=2.683103e-17
+ wuc1=-9.71032e-18 puc1=1.788616e-23 kt1l=0
+ prt=0 cj=cjn3m mj=0.3648985
+ pb=0.854642 cjsw=cjswn3m mjsw=0.1862273
+ pbsw=0.854642 cjswg=cjswng3m mjswg=0.1862273
+ pbswg=0.854642 tcj=7.51721e-4 tcjsw=3.394091e-4
+ tcjswg=3.394091e-4 tpb=1.714381e-3 tpbsw=1.714381e-3
+ tpbswg=1.714381e-3 cgdo=cgon3m cgso=cgon3m
+ js=2e-6 jsw=1.0029e-11 capmod=3
+ xti=3 n=1 nqsmod=0
+ xpart=1 cf=0 tlev=1
+ tlevc=1 hdif=hdifn3m
+ llc=-0.012
+ minr=1e-60 imax=0.01 imelt=0.01
endsection mos3m
//
//  *********************************
//                                  *
//  0.18um 1.8V PNP AND NPN bipolar *
//                                  *
//  *********************************
section tt_bip
parameters isa=1
parameters bfa=1
parameters nfa=1
parameters rba=1
parameters rea=1
parameters rca=1
parameters rbma=1
parameters cjea=1
parameters cjca=1
include "rf018.scs" section=bip
endsection tt_bip

section ss_bip
parameters isa=0.70
parameters bfa=0.85
parameters nfa=1.005
parameters rba=1.2
parameters rea=1.2
parameters rca=1.2
parameters rbma=1.2
parameters cjea=1.05
parameters cjca=1.05
include "rf018.scs" section=bip
endsection ss_bip

section ff_bip
parameters isa=1.30
parameters bfa=1.15
parameters nfa=0.995
parameters rba=0.8
parameters rea=0.8
parameters rca=0.8
parameters rbma=0.8
parameters cjea=0.95
parameters cjca=0.95
include "rf018.scs" section=bip
endsection ff_bip

section bip
//
model pnp5 bjt type=pnp minr=1e-60 rbmod=spice bf=2.775 * bfa nf=1.013 * nfa is=3.5351e-18 * isa
+ ise=3.5351e-18 * isa isc=3.5351e-18 * isa ne=1.3977142 rb=54.76734 * rba irb=1.401332e-3
+ rbm=1.0965611 * rbma re=1.3979963 * rea ikf=8.2254e-4 nkf=0.477972 vaf=372.731
+ br=4.4013e-3 nr=0.993881 nc=0.98076 rc=20.08 * rca ikr=1.98804e-4 var=20.84541
+ xti=3 eg=1.17 xtb=0 trb1=1.493714e-3 tirb1=1.375303e-5 trm1=1.074565e-5 tre1=1.068665e-4
+ tikf1=-2.512025e-3 tikr1=-3.93e-3 trc1=8e-5 tbf1=4.9e-3 tbf2=1.1e-6 tnf1=-1.056025e-4
+ tne1=2.152336e-4 tvaf1=-4e-5 tbr1=-1.01e-3 tbr2=1.3e-5 tnc1=1.122277e-4 tnc2=0
+ tnr1=-1.026101e-4 tnr2=0 cje=3.2987e-14 * cjea vje=0.895226 mje=0.4345495 fc=0
+ cjc=3.965229e-14 * cjca vjc=0.5846489 mjc=0.2933243 tlev=0 tlevc=1 cte=2.0325e-3
+ ctc=8.900197e-4 tvje=1.572025e-3 tvjc=2.819e-3 tnom=25
//
model pnp10 bjt type=pnp minr=1e-60 rbmod=spice bf=2.715 * bfa nf=1.01 * nfa is=1.5353e-17 * isa
+ ise=1.5353e-17 * isa isc=1.5353e-17 * isa ne=1.2977142 rb=36.063401 * rba irb=1.401332e-3
+ rbm=1.0965611 * rbma re=1.3979963 * rea ikf=1.72254e-3 nkf=0.477972 vaf=361.145
+ br=0.0114433 nr=0.9908706 nc=0.9007513 rc=20.08 * rca ikr=1.98804e-4 var=20.84541
+ xti=3 eg=1.17 xtb=0 trb1=1.493714e-3 tirb1=1.375303e-5 trm1=1.074565e-5 tre1=1.068665e-4
+ tikf1=-3.912025e-3 tikr1=-3.93e-3 trc1=8e-5 tbf1=4.91e-3 tbf2=1e-6 tnf1=-1.0025e-4
+ tne1=2.00234e-4 tvaf1=-5e-3 tbr1=-3.15e-3 tbr2=3.5e-5 tnc1=8.022278e-5 tnc2=0
+ tnr1=-2.025978e-4 tnr2=0 cje=1.22024e-13 * cjea vje=0.895226 mje=0.4405495 fc=0
+ cjc=6.837658e-14 * cjca vjc=0.5846489 mjc=0.3033243 tlev=0 tlevc=1 cte=9.300197e-4
+ ctc=2.1425e-3 tvje=1.572025e-3 tvjc=2.819e-3 tnom=25
//
model pnp2 bjt type=pnp minr=1e-60 rbmod=spice bf=2.7551 * bfa nf=1.013 * nfa is=9.03515e-19 *
+ isa ise=9.03515e-19 * isa isc=9.03515e-19 * isa ne=1.2977142 rb=102.76734 * rba
+ irb=1.401332e-3 rbm=1.0965611 * rbma re=1.297997 * rea ikf=3.02541e-4 nkf=0.427981
+ vaf=126.168 br=1.3713e-3 nr=0.993671 nc=0.920748 rc=20.08 * rca ikr=1.98804e-4
+ var=15.6151 xti=3 eg=1.17 xtb=0 trb1=1.493714e-3 tirb1=1.375303e-5 trm1=1.074565e-5
+ tre1=1.068665e-4 tikf1=-4.31203e-3 tikr1=-3.93e-3 trc1=8e-5 tbf1=5.85e-3 tbf2=3e-6
+ tnf1=-1.056025e-4 tne1=2.152336e-4 tvaf1=-1e-3 tbr1=-1.5e-3 tbr2=1.85e-5 tnc1=1.122198e-4
+ tnc2=0 tnr1=-2.425601e-4 tnr2=0 cje=6.4688e-15 * cjea vje=0.895226 mje=0.4205495
+ fc=0 cjc=2.562787e-14 * cjca vjc=0.5846489 mjc=0.2833243 tlev=0 tlevc=1 cte=8.000197e-4
+ ctc=1.9025e-3 tvje=1.572025e-3 tvjc=2.819e-3 tnom=25
//
model npn10 bjt type=npn minr=1e-60 rbmod=spice bf=25.7 * bfa nf=1.01 * nfa ise=2.88886e-17 * isa
+ ne=1.22 is=2.88886e-17 * isa rb=30 * rba irb=1e-3 rbm=1.5 * rbma re=20 * rea ikf=0.0134151
+ nkf=0.4538405 vaf=46.5899168 br=2.95 nr=0.9886811 tlev=0 isc=2.88886e-17 * isa
+ nc=1.0197608 rc=12 * rca ikr=3.753206e-3 var=27.600531 xti=3 eg=1.17 xtb=0 tbf1=6.1e-3
+ tbf2=8e-6 trb1=0.015 tikf1=-5e-3 tikr1=5e-3 tbr1=4.5e-3 tbr2=-1e-6 tne1=5e-4 cje=1.09057e-13
+ * cjea vje=0.7458 mje=0.374 cte=9.987e-4 tvje=1.6073e-3 cjc=1.99861e-13 * cjca
+ vjc=0.958319 mjc=0.412462 ctc=7.5e-4 tvjc=2.16348e-3 tlevc=1 fc=0 tnom=25
//
//
model npn5 bjt type=npn minr=1e-60 rbmod=spice bf=26.7 * bfa nf=1.013 * nfa ise=8.45141e-18 * isa
+ ne=1.22 is=8.45141e-18 * isa rb=30 * rba irb=1e-3 rbm=1.5 * rbma re=25 * rea ikf=8.03653e-3
+ nkf=0.5097973 vaf=46.4089369 br=0.98 nr=0.987839 tlev=0 isc=8.45141e-18 * isa
+ nc=1.0244644 rc=15 * rca ikr=4e-3 var=28.110846 xti=3 eg=1.17 xtb=0 tbf1=6.4e-3
+ tbf2=1e-5 trb1=0.015 tikf1=-6e-3 tikr1=5e-3 trc1=8e-4 tbr1=1.9e-3 tbr2=-5e-6 tne1=4.6e-4
+ cje=2.96049e-14 * cjea vje=0.7458 mje=0.374 cte=9.987e-4 tvje=1.6073e-3 cjc=1.03356e-13
+ * cjca vjc=0.958319 mjc=0.412462 ctc=7.5e-4 tvjc=2.16348e-3 tlevc=1 fc=0 tnom=25
+
//
//
model npn2 bjt type=npn minr=1e-60 rbmod=spice bf=28.2 * bfa nf=1.012 * nfa ise=1.970838e-18 *
+ isa ne=1.22 is=1.970838e-18 * isa rb=40 * rba irb=1e-3 rbm=2.0 * rbma re=30 *
+ rea ikf=3.25342e-3 nkf=0.5554402 vaf=47.6877977 br=0.302 nr=0.9869396 tlev=0 isc=1.970838e-18
+ nc=1.0205444 rc=20 * rca ikr=4.740015e-3 var=28.292768 xti=3 eg=1.17 xtb=0 tbf1=7.2e-3
+ tbf2=1.2e-5 tikf1=-5e-3 tbr1=1.4e-3 tbr2=-5e-6 tne1=2e-4 cje=5.86024e-15 * cjea
+ vje=0.7458 mje=0.374 cte=9.987e-4 tvje=1.6073e-3 cjc=6.03101e-14 * cjca vjc=0.958319
+ mjc=0.412462 ctc=7.5e-4 tvjc=2.16348e-3 tlevc=1 fc=0 tnom=25
//
endsection bip
//  ***********************
//                        *
//  0.18um   3.3V bipolar *
//                        *
//  ***********************
section tt_bip3
parameters isa3=1
parameters bfa3=1
parameters nfa3=1
parameters rba3=1
parameters rea3=1
parameters rca3=1
parameters rbma3=1
parameters cjea3=1
parameters cjca3=1
include "rf018.scs" section=bip3
endsection tt_bip3

section ss_bip3
parameters isa3=0.70
parameters bfa3=0.85
parameters nfa3=1.005
parameters rba3=1.2
parameters rea3=1.2
parameters rca3=1.2
parameters rbma3=1.2
parameters cjea3=1.05
parameters cjca3=1.05
include "rf018.scs" section=bip3
endsection ss_bip3

section ff_bip3
parameters isa3=1.30
parameters bfa3=1.15
parameters nfa3=0.995
parameters rba3=0.8
parameters rea3=0.8
parameters rca3=0.8
parameters rbma3=0.8
parameters cjea3=0.95
parameters cjca3=0.95
include "rf018.scs" section=bip3
endsection ff_bip3

section bip3
//
model pnp10_3 bjt type=pnp minr=1e-60 rbmod=spice bf=2.715 * bfa3 nf=1.011 * nfa3 is=1.5353e-17
+ * isa3 ise=1.5353e-17 * isa3 isc=1.5353e-17 * isa3 ne=1.2977142 rb=33.063401 *
+ rba3 irb=1.401332e-3 rbm=1.0965611 * rbma3 re=1.3979963 * rea3 ikf=2.05254e-3
+ nkf=0.477972 vaf=361.145 br=9.0433e-3 nr=0.9908706 nc=0.9007513 rc=20.08 * rca3
+ ikr=1.98804e-4 var=27.84541 xti=3 eg=1.17 xtb=0 trb1=1.493714e-3 tirb1=1.375303e-5
+ trm1=1.074565e-5 tre1=1.068665e-4 tikf1=-3.912025e-3 tikr1=-3.93e-3 trc1=8e-5
+ tbf1=5.11e-3 tbf2=1e-6 tnf1=-1.0025e-4 tne1=2.00234e-4 tvaf1=-5e-3 tbr1=-1.95e-3
+ tbr2=2.25e-5 tnc1=8.022278e-5 tnc2=0 tnr1=-2.025978e-4 tnr2=0 cje=1.124556e-13
+ * cjea3 vje=0.8049122 mje=0.3845495 fc=0 cjc=6.353976e-14 * cjca3 vjc=0.5846489
+ mjc=0.2883243 tlev=0 tlevc=1 cte=9.700197e-4 ctc=1.9425e-3 tvje=1.625007e-3 tvjc=2.819e-3
+ tnom=25
//
model pnp5_3 bjt type=pnp minr=1e-60 rbmod=spice bf=2.725 * bfa3 nf=1.011 * nfa3 is=3.5351e-18
+ * isa3 ise=3.5351e-18 * isa3 isc=3.5351e-18 * isa3 ne=1.3977142 rb=54.76734 *
+ rba3 irb=1.401332e-3 rbm=1.0965611 * rbma3 re=1.3979963 * rea3 ikf=1.1254e-3 nkf=0.477972
+ vaf=372.731 br=3.5513e-3 nr=0.993881 nc=0.98076 rc=20.08 * rca3 ikr=1.98804e-4
+ var=22.44541 xti=3 eg=1.17 xtb=0 trb1=1.493714e-3 tirb1=1.375303e-5 trm1=1.074565e-5
+ tre1=1.068665e-4 tikf1=-2.752025e-3 tikr1=-3.93e-3 trc1=8e-5 tbf1=5.2e-3 tbf2=1.1e-6
+ tnf1=-1.056025e-4 tne1=2.152336e-4 tvaf1=-4e-5 tbr1=-1.01e-3 tbr2=1.3e-5 tnc1=1.122277e-4
+ tnc2=0 tnr1=-1.026101e-4 tnr2=0 cje=3.034505e-14 * cjea3 vje=0.8049122 mje=0.3745495
+ fc=0 cjc=3.728498e-14 * cjca3 vjc=0.5846489 mjc=0.2783243 tlev=0 tlevc=1 cte=9.500197e-4
+ ctc=2.0325e-3 tvje=1.625007e-3 tvjc=3.009e-3 tnom=25
//
model pnp2_3 bjt type=pnp minr=1e-60 rbmod=spice bf=2.7351 * bfa3 nf=1.012 * nfa3 is=8.03515e-19
+ * isa3 ise=8.03515e-19 * isa3 isc=8.03515e-19 * isa3 ne=1.2977142 rb=102.76734
+ * rba3 irb=1.401332e-3 rbm=1.0965611 * rbma3 re=1.297997 * rea3 ikf=4.02541e-4
+ nkf=0.427981 vaf=126.168 br=1.1153e-3 nr=1.013671 nc=0.920748 rc=20.08 * rca3
+ ikr=1.98804e-4 var=20.0151 xti=3 eg=1.17 xtb=0 trb1=1.493714e-3 tirb1=1.375303e-5
+ trm1=1.074565e-5 tre1=1.068665e-4 tikf1=-4.31203e-3 tikr1=-3.93e-3 trc1=8e-5 tbf1=5.85e-3
+ tbf2=3e-6 tnf1=-1.056025e-4 tne1=2.152336e-4 tvaf1=-1e-3 tbr1=-1.5e-3 tbr2=1.65e-5
+ tnc1=1.122198e-4 tnc2=0 tnr1=-2.425601e-4 tnr2=0 cje=5.92616e-15 * cjea3 vje=0.8049122
+ mje=0.3495495 fc=0 cjc=2.432423e-14 * cjca3 vjc=0.5846489 mjc=0.2673243 tlev=0
+ tlevc=1 cte=9.000197e-4 ctc=1.9025e-3 tvje=1.625007e-3 tvjc=2.959e-3 tnom=25
//
endsection bip3
//
// ************************
//                        *
//  0.18um   1.8V diode   *
//                        *
// ************************
//
section dio
//
inline subckt ndio (1 2)
parameters area=7.5e-8 pj=1.1e-3 rs=1.0e-10
  r1 (1 3) resistor r=rs/area tc1=1.62e-3
  diode (3 2) ndio_D area=area pj=pj
ends ndio
model ndio_D diode
+ level=1                   is=3.50e-7                n=1.03
+ bv=11.10                  ibv=1e-3                  isw=4.00e-13
+ cj=1.000266e-3            vj=0.6882682              mj=0.3595262
+ cjsw=2.040547e-10         vjsw=0.6882682            mjsw=0.2003879
+ tlev=1                    eg=1.17                   xti=3
+ tbv1=-1*-9.3e-4           tlevc=1                   cta=1.040287e-3
+ ctp=6.45489e-4            pta=1.554306e-3           ptp=1.554306e-3
+ tnom=25                   fc=0                      ns=1.03
+ nz=1.03                   imax=1e40                 minr=1e-10
+ allow_scaling=1
//
inline subckt pdio (1 2)
parameters area=7.5e-8 pj=1.1e-3 rs=1.0e-10
  r1 (1 3) resistor r=rs/area tc1=1.2e-4
  diode (3 2) pdio_D area=area pj=pj
ends pdio
model pdio_D diode
+ level=1                   is=2.50e-7                n=1.03
+ bv=10.1                   ibv=1e-3                  isw=4.00e-13
+ cj=1.121e-3               vj=0.895226               mj=0.4476
+ cjsw=2.481e-10            vjsw=0.895226             mjsw=0.3683619
+ tlev=1                    eg=1.17                   xti=3
+ tbv1=-1*-8.8e-4           tlevc=1                   cta=9.739001e-4
+ ctp=4.130718e-4           pta=1.572025e-3           ptp=1.572025e-3
+ tnom=25                   fc=0                      ns=1.03
+ nz=1.03                   imax=1e40                 minr=1e-10
+ allow_scaling=1
//
inline subckt nwdio (1 2)
parameters area=7.5e-8 pj=1.1e-3 rs=1.0e-10
  r1 (1 3) resistor r=rs/area tc1=1.125e-3
  diode (3 2) nwdio_D area=area pj=pj
ends nwdio
model nwdio_D diode
+ level=1                   is=6.50e-7                n=1.03
+ bv=14.75                  ibv=1e-3                  isw=9.75e-13
+ cj=1.337566e-4            vj=0.5846489              mj=0.3883243
+ cjsw=5.333577e-10         vjsw=0.5846489            mjsw=0.2345684
+ tlev=1                    eg=1.17                   xti=3
+ tbv1=-1*-9.6e-4           tlevc=1                   cta=2.8425e-3
+ ctp=1.5284e-3             pta=2.819e-3              ptp=2.819e-3
+ tnom=25                   fc=0                      ns=1.03
+ nz=1.03                   imax=1e40                 minr=1e-10
+ allow_scaling=1
//
endsection dio
//
// ********************************
//                                *
//  0.18um   3.3V and ESD diode   *
//                                *
// ********************************
//
section dio3
//
inline subckt ndio_3 (1 2)
parameters area=7.5e-8 pj=1.1e-3 rs=1.0e-10
  r1 (1 3) resistor r=rs/area tc1=1.62e-3
  diode (3 2) ndio_3_D area=area pj=pj
ends ndio_3
model ndio_3_D diode
+ level=1                   is=3.93e-7                n=1.0
+ bv=10.84                  ibv=1e-3                  isw=3.54e-13
+ cj=8.964788e-4            vj=0.7076023              mj=0.3259624
+ cjsw=2.50664e-10          vjsw=0.7076023            mjsw=0.1513672
+ tlev=1                    eg=1.17                   xti=3
+ tbv1=-1*-8.33e-4          tlevc=1                   cta=9.923959e-4
+ ctp=5.019466e-4           pta=1.687207e-3           ptp=1.687207e-3
+ tnom=25                   fc=0                      ns=1.0
+ nz=1.0                    imax=1e40                 minr=1e-10
+ allow_scaling=1
//
inline subckt pdio_3 (1 2)
parameters area=7.5e-8 pj=1.1e-3 rs=1.0e-10
  r1 (1 3) resistor r=rs/area tc1=1.2e-4
  diode (3 2) pdio_3_D area=area pj=pj
ends pdio_3
model pdio_3_D diode
+ level=1                   is=1.900e-7               n=1.0
+ bv=10.3                   ibv=1e-3                  isw=5.02e-13
+ cj=1.03531e-3             vj=0.8049122              mj=0.3954951
+ cjsw=2.23115e-10          vjsw=0.8049122            mjsw=0.2573111
+ tlev=1                    eg=1.17                   xti=3
+ tbv1=-1*-8.1e-4           tlevc=1                   cta=9.940197e-4
+ ctp=6.908749e-4           pta=1.625007e-3           ptp=1.625007e-3
+ tnom=25                   fc=0                      ns=1.0
+ nz=1.0                    imax=1e40                 minr=1e-10
+ allow_scaling=1
//
inline subckt nwdio_3 (1 2)
parameters area=7.5e-8 pj=1.1e-3 rs=1.0e-10
  r1 (1 3) resistor r=rs/area tc1=1.125e-3
  diode (3 2) nwdio_3_D area=area pj=pj
ends nwdio_3
model nwdio_3_D diode
+ level=1                   is=6.50e-7                n=1.03
+ bv=14.75                  ibv=1e-3                  isw=9.75e-13
+ cj=1.337566e-4            vj=0.5846489              mj=0.3883243
+ cjsw=5.333577e-10         vjsw=0.5846489            mjsw=0.2345684
+ tlev=1                    eg=1.17                   xti=3
+ tbv1=-1*-9.6e-4           tlevc=1                   cta=2.8425e-3
+ ctp=1.5284e-3             pta=2.819e-3              ptp=2.819e-3
+ tnom=25                   fc=0                      ns=1.03
+ nz=1.03                   imax=1e40                 minr=1e-10
+ allow_scaling=1
//
inline subckt endio_3 (1 2)
parameters area=1e-13 pj=0 rs=1.0e-10
  r1 (1 3) resistor r=rs/area tc1=1.125e-3
  diode (3 2) adio area=area pj=pj
ends endio_3
model  adio diode level=1
+ cj=1.416999e-3 vj=0.6798575 mj=0.3357974 imax=1e40
+ tnom=25 fc=0
//
//
endsection dio3

section dio_dnw
//
// **************************************************************
//                    MODEL OF DNW/PSUB DIODE                   *
//                                                              *
// **************************************************************
inline subckt dnwpsub (1 2)
parameters area=4.0044e-8 pj=8.48e-4 rs=1.0e-10
  r1 (1 3) resistor r=rs/area tc1=3.35e-3
  diode (3 2) dnwpsub_D area=area pj=pj
ends dnwpsub
model dnwpsub_D diode
+ level=1                   is=1.40e-6                n=1.03
+ bv=14.70                  ibv=1e-3                  isw=1.10e-12
+ cj=1.40e-4                vj=0.8                    mj=0.490
+ cjsw=1.12e-9              vjsw=0.8                  mjsw=0.35
+ tlev=1                    eg=1.17                   xti=3
+ tbv1=-1*-9.40e-4          tlevc=1                   cta=2.25e-3
+ ctp=1.60e-3               pta=2.80e-3               ptp=2.80e-3
+ tnom=25                   fc=0                      ns=1.03
+ nz=1.03                   imax=1e40                 minr=1e-10
+ allow_scaling=1
//
// **************************************************************
//                     MODEL OF PW/DNW DIODE                    *
//                                                              *
// **************************************************************
//
inline subckt pwdnw (1 2)
parameters area=4.0044e-8 pj=8.48e-4 rs=1.0e-10
  r1 (1 3) resistor r=rs/area tc1=3.44e-3
  diode (3 2) pwdnw_D area=area pj=pj
ends pwdnw
model pwdnw_D diode
+ level=1                   is=1.20e-6                n=1.03
+ bv=14.50                  ibv=1e-3                  isw=1.0e-12
+ cj=6.80e-4                vj=0.585                  mj=0.350
+ cjsw=5.33e-10             vjsw=0.585                mjsw=0.235
+ tlev=1                    eg=1.17                   xti=3
+ tbv1=-1*-1.10e-3          tlevc=1                   cta=1.0e-3
+ ctp=1.53e-3               pta=1.4e-3                ptp=2.82e-3
+ tnom=25                   fc=0                      ns=1.03
+ nz=1.03                   imax=1e40                 minr=1e-10
+ allow_scaling=1
//
endsection dio_dnw

//  ******************************
//                               *
//    0.18um  resistor model     *
//                               *
//  ******************************
//
section tt_res
parameters r_rnod=6.82
parameters r_rnodw=6.82
parameters r_rpod=7.76
parameters r_rpodw=7.76
parameters r_rnodrpo=59
parameters r_rpodrpo=133
parameters r_rnwod=440
parameters r_rnwsti=927
parameters r_rnpo1=7.89
parameters r_rnpo1w=7.89
parameters r_rppo1=7.9
parameters r_rppo1w=7.9
parameters r_rnpo1rpo=292
parameters r_rppo1rpo=311
parameters r_rppolyhri=1075.37
parameters r_rm1=0.078
parameters r_rm2=0.078
parameters r_rm3=0.078
parameters r_rm4=0.078
parameters r_rm5=0.078
parameters r_rmt=0.0178
include "rf018.scs" section=res
//include "rf018.scs" section=dio
endsection tt_res
//
section ss_res
parameters r_rnod=6.82 + 2.5
parameters r_rnodw=6.82 + 2.5
parameters r_rpod=7.76 + 3
parameters r_rpodw=7.76 + 3
parameters r_rnodrpo=59 + 5.8
parameters r_rpodrpo=133 + 19
parameters r_rnwod=440 + 100
parameters r_rnwsti=927 + 132
parameters r_rnpo1=7.89 + 2
parameters r_rnpo1w=7.89 + 2
parameters r_rppo1=7.9 + 2.5
parameters r_rppo1w=7.9 + 2.5
parameters r_rnpo1rpo=292 + 43.8
parameters r_rppo1rpo=311 + 46.65
parameters r_rppolyhri=1075.37 + 161.3
parameters r_rm1=0.078 + 0.023
parameters r_rm2=0.078 + 0.023
parameters r_rm3=0.078 + 0.023
parameters r_rm4=0.078 + 0.023
parameters r_rm5=0.078 + 0.023
parameters r_rmt=0.0178 + 0.00623
include "rf018.scs" section=res
//include "rf018.scs" section=dio
endsection ss_res
//
section ff_res
parameters r_rnod=6.82 - 2.5
parameters r_rnodw=6.82 - 2.5
parameters r_rpod=7.76 - 3
parameters r_rpodw=7.76 - 3
parameters r_rnodrpo=59 - 5.8
parameters r_rpodrpo=133 - 19
parameters r_rnwod=440 - 100
parameters r_rnwsti=927 - 132
parameters r_rnpo1=7.89 - 2
parameters r_rnpo1w=7.89 - 2
parameters r_rppo1=7.9 - 2.5
parameters r_rppo1w=7.9 - 2.5
parameters r_rnpo1rpo=292 - 43.8
parameters r_rppo1rpo=311 - 46.65
parameters r_rppolyhri=1075.37 - 161.3
parameters r_rm1=0.078 - 0.023
parameters r_rm2=0.078 - 0.023
parameters r_rm3=0.078 - 0.023
parameters r_rm4=0.078 - 0.023
parameters r_rm5=0.078 - 0.023
parameters r_rmt=0.0178 - 0.00623
include "rf018.scs" section=res
//include "rf018.scs" section=dio
endsection ff_res
//
section res
//ahdl_include "res_va.va"
//ahdl_include "res_polywo.va"
//
subckt rnod n1 n2
parameters w=1u l=1u mf=1 rsh=r_rnod dw=-0.0765u tc1=3.35e-3 tc2=4.31e-7 vc1=7.56e-5
+ vc2=1.24e-3 pt=temp tfac=1.0 + tc1 * (pt - 25.0) + tc2 * (pt - 25.0) * (pt
+ - 25.0)
//
R1 (n1 n2) bsource r=(rsh/mf) * (l / (w - dw)) * (1 + vc1 * abs(v(n1,n2)) + vc2 * v(n1,n2)
+ * v(n1,n2)) * tfac
//
ends rnod

subckt rnod_m n2 n1 body
parameters w=1u l=1u mf=1 rsh=r_rnod dw=-0.0765u tc1=3.35e-3 tc2=4.31e-7 vc1=7.56e-5
+ vc2=1.24e-3 pt=temp tfac=1.0 + tc1 * (pt - 25.0) + tc2 * (pt - 25.0) * (pt
+ - 25.0)
R1 (n2 nm n2 n1) bsource r=(rsh/mf) * ((l/4) / (w - dw)) * (1 + vc1 * abs(v(n2,n1)) + vc2 * v(n2,n1) * v(n2,n1)) * tfac
R2 (nm nn n2 n1) bsource r=(rsh/mf) * ((l/4) / (w - dw)) * (1 + vc1 * abs(v(n2,n1)) + vc2 * v(n2,n1) * v(n2,n1)) * tfac
R3 (nn nx n2 n1) bsource r=(rsh/mf) * ((l/4) / (w - dw)) * (1 + vc1 * abs(v(n2,n1)) + vc2 * v(n2,n1) * v(n2,n1)) * tfac
R4 (nx n1 n2 n1) bsource r=(rsh/mf) * ((l/4) / (w - dw)) * (1 + vc1 * abs(v(n2,n1)) + vc2 * v(n2,n1) * v(n2,n1)) * tfac
d1 (body n2) ndio area=mf*(w-dw)*l/5.0 pj=mf*(w-dw)+2.0*l/5.0
d2 (body nm) ndio area=mf*(w-dw)*l/5.0 pj=mf*2.0*l/5.0
d3 (body nn) ndio area=mf*(w-dw)*l/5.0 pj=mf*2.0*l/5.0
d4 (body nx) ndio area=mf*(w-dw)*l/5.0 pj=mf*2.0*l/5.0
d5 (body n1) ndio area=mf*(w-dw)*l/5.0 pj=mf*(w-dw)+2.0*l/5.0
ends rnod_m

subckt rnodw n1 n2
parameters w=1u l=1u mf=1 rsh=r_rnodw dw=-0.0765u tc1=3.35e-3 tc2=4.31e-7 vc1=7.56e-5
+ vc2=1.24e-3 pt=temp tfac=1.0 + tc1 * (pt - 25.0) + tc2 * (pt - 25.0) * (pt
+ - 25.0)
//
R1 (n1 n2) bsource r=(rsh/mf) * (l / (w - dw)) * (1 + vc1 * abs(v(n1,n2)) + vc2 * v(n1,n2)
+ * v(n1,n2)) * tfac
//
ends rnodw

subckt rnodw_m n2 n1 body
parameters w=1u l=1u mf=1 rsh=r_rnodw dw=-0.0765u tc1=3.35e-3 tc2=4.31e-7 vc1=7.56e-5
+ vc2=1.24e-3 pt=temp tfac=1.0 + tc1 * (pt - 25.0) + tc2 * (pt - 25.0) * (pt
+ - 25.0)
R1 (n2 nm n2 n1) bsource r=(rsh/mf) * ((l/4) / (w - dw)) * (1 + vc1 * abs(v(n2,n1)) + vc2 * v(n2,n1) * v(n2,n1)) * tfac
R2 (nm nn n2 n1) bsource r=(rsh/mf) * ((l/4) / (w - dw)) * (1 + vc1 * abs(v(n2,n1)) + vc2 * v(n2,n1) * v(n2,n1)) * tfac
R3 (nn nx n2 n1) bsource r=(rsh/mf) * ((l/4) / (w - dw)) * (1 + vc1 * abs(v(n2,n1)) + vc2 * v(n2,n1) * v(n2,n1)) * tfac
R4 (nx n1 n2 n1) bsource r=(rsh/mf) * ((l/4) / (w - dw)) * (1 + vc1 * abs(v(n2,n1)) + vc2 * v(n2,n1) * v(n2,n1)) * tfac
d1 (body n2) ndio area=mf*(w-dw)*l/5.0 pj=mf*(w-dw)+2.0*l/5.0
d2 (body nm) ndio area=mf*(w-dw)*l/5.0 pj=mf*2.0*l/5.0
d3 (body nn) ndio area=mf*(w-dw)*l/5.0 pj=mf*2.0*l/5.0
d4 (body nx) ndio area=mf*(w-dw)*l/5.0 pj=mf*2.0*l/5.0
d5 (body n1) ndio area=mf*(w-dw)*l/5.0 pj=mf*(w-dw)+2.0*l/5.0
ends rnodw_m

subckt rpod n1 n2
parameters w=1u l=1u mf=1 rsh=r_rpod dw=-0.08u tc1=3.44e-3 tc2=5.02e-7 vc1=-2.51e-4
+ vc2=1.03e-3 pt=temp tfac=1.0 + tc1 * (pt - 25.0) + tc2 * (pt - 25.0) * (pt
+ - 25.0)
//
R1 (n1 n2) bsource r=(rsh/mf) * (l / (w - dw)) * (1 + vc1 * abs(v(n1,n2)) + vc2 * v(n1,n2)
+ * v(n1,n2)) * tfac
//
ends rpod

subckt rpod_m n2 n1 body
parameters w=1u l=1u mf=1 rsh=r_rpod dw=-0.08u tc1=3.44e-3 tc2=5.02e-7 vc1=-2.51e-4
+ vc2=1.03e-3 pt=temp tfac=1.0 + tc1 * (pt - 25.0) + tc2 * (pt - 25.0) * (pt
+ - 25.0)
R1 (n2 nm n2 n1) bsource r=(rsh/mf) * ((l/4) / (w - dw)) * (1 + vc1 * abs(v(n2,n1)) + vc2 * v(n2,n1) * v(n2,n1)) * tfac
R2 (nm nn n2 n1) bsource r=(rsh/mf) * ((l/4) / (w - dw)) * (1 + vc1 * abs(v(n2,n1)) + vc2 * v(n2,n1) * v(n2,n1)) * tfac
R3 (nn nx n2 n1) bsource r=(rsh/mf) * ((l/4) / (w - dw)) * (1 + vc1 * abs(v(n2,n1)) + vc2 * v(n2,n1) * v(n2,n1)) * tfac
R4 (nx n1 n2 n1) bsource r=(rsh/mf) * ((l/4) / (w - dw)) * (1 + vc1 * abs(v(n2,n1)) + vc2 * v(n2,n1) * v(n2,n1)) * tfac
d1 (n2 body) pdio area=mf*(w-dw)*l/5.0 pj=mf*(w-dw)+2.0*l/5.0
d2 (nm body) pdio area=mf*(w-dw)*l/5.0 pj=mf*2.0*l/5.0
d3 (nn body) pdio area=mf*(w-dw)*l/5.0 pj=mf*2.0*l/5.0
d4 (nx body) pdio area=mf*(w-dw)*l/5.0 pj=mf*2.0*l/5.0
d5 (n1 body) pdio area=mf*(w-dw)*l/5.0 pj=mf*(w-dw)+2.0*l/5.0
ends rpod_m

subckt rpodw n1 n2
parameters w=1u l=1u mf=1 rsh=r_rpodw dw=-0.08u tc1=3.44e-3 tc2=5.02e-7 vc1=-2.51e-4
+ vc2=1.03e-3 pt=temp tfac=1.0 + tc1 * (pt - 25.0) + tc2 * (pt - 25.0) * (pt
+ - 25.0)
//
R1 (n1 n2) bsource r=(rsh/mf) * (l / (w - dw)) * (1 + vc1 * abs(v(n1,n2)) + vc2 * v(n1,n2)
+ * v(n1,n2)) * tfac
//
ends rpodw

subckt rpodw_m n2 n1 body
parameters w=1u l=1u mf=1 rsh=r_rpodw dw=-0.08u tc1=3.44e-3 tc2=5.02e-7 vc1=-2.51e-4
+ vc2=1.03e-3 pt=temp tfac=1.0 + tc1 * (pt - 25.0) + tc2 * (pt - 25.0) * (pt
+ - 25.0)
R1 (n2 nm n2 n1) bsource r=(rsh/mf) * ((l/4) / (w - dw)) * (1 + vc1 * abs(v(n2,n1)) + vc2 * v(n2,n1) * v(n2,n1)) * tfac
R2 (nm nn n2 n1) bsource r=(rsh/mf) * ((l/4) / (w - dw)) * (1 + vc1 * abs(v(n2,n1)) + vc2 * v(n2,n1) * v(n2,n1)) * tfac
R3 (nn nx n2 n1) bsource r=(rsh/mf) * ((l/4) / (w - dw)) * (1 + vc1 * abs(v(n2,n1)) + vc2 * v(n2,n1) * v(n2,n1)) * tfac
R4 (nx n1 n2 n1) bsource r=(rsh/mf) * ((l/4) / (w - dw)) * (1 + vc1 * abs(v(n2,n1)) + vc2 * v(n2,n1) * v(n2,n1)) * tfac
d1 (n2 body) pdio area=mf*(w-dw)*l/5.0 pj=mf*(w-dw)+2.0*l/5.0
d2 (nm body) pdio area=mf*(w-dw)*l/5.0 pj=mf*2.0*l/5.0
d3 (nn body) pdio area=mf*(w-dw)*l/5.0 pj=mf*2.0*l/5.0
d4 (nx body) pdio area=mf*(w-dw)*l/5.0 pj=mf*2.0*l/5.0
d5 (n1 body) pdio area=mf*(w-dw)*l/5.0 pj=mf*(w-dw)+2.0*l/5.0
ends rpodw_m

subckt rnodrpo n1 n2
parameters w=1u l=1u mf=1 rsh=r_rnodrpo dw=0.0u tc1=1.47e-3 tc2=8.32e-7 vc1=7.55e-4
+ vc2=1.97e-4 pt=temp tfac=1.0 + tc1 * (pt - 25.0) + tc2 * (pt - 25.0) * (pt
+ - 25.0)
//
R1 (n1 n2) bsource r=(rsh/mf) * (l / (w - dw)) * (1 + vc1 * abs(v(n1,n2)) + vc2 * v(n1,n2)
+ * v(n1,n2)) * tfac
//
ends rnodrpo

subckt rnodrpo_m n2 n1 body
parameters w=1u l=1u mf=1 rsh=r_rnodrpo dw=0.0u tc1=1.47e-3 tc2=8.32e-7 vc1=7.55e-4
+ vc2=1.97e-4 pt=temp tfac=1.0 + tc1 * (pt - 25.0) + tc2 * (pt - 25.0) * (pt
+ - 25.0)
R1 (n2 nm n2 n1) bsource r=(rsh/mf) * ((l/4) / (w - dw)) * (1 + vc1 * abs(v(n2,n1)) + vc2 * v(n2,n1) * v(n2,n1)) * tfac
R2 (nm nn n2 n1) bsource r=(rsh/mf) * ((l/4) / (w - dw)) * (1 + vc1 * abs(v(n2,n1)) + vc2 * v(n2,n1) * v(n2,n1)) * tfac
R3 (nn nx n2 n1) bsource r=(rsh/mf) * ((l/4) / (w - dw)) * (1 + vc1 * abs(v(n2,n1)) + vc2 * v(n2,n1) * v(n2,n1)) * tfac
R4 (nx n1 n2 n1) bsource r=(rsh/mf) * ((l/4) / (w - dw)) * (1 + vc1 * abs(v(n2,n1)) + vc2 * v(n2,n1) * v(n2,n1)) * tfac
d1 (body n2) ndio area=mf*(w-dw)*l/5.0 pj=mf*(w-dw)+2.0*l/5.0
d2 (body nm) ndio area=mf*(w-dw)*l/5.0 pj=mf*2.0*l/5.0
d3 (body nn) ndio area=mf*(w-dw)*l/5.0 pj=mf*2.0*l/5.0
d4 (body nx) ndio area=mf*(w-dw)*l/5.0 pj=mf*2.0*l/5.0
d5 (body n1) ndio area=mf*(w-dw)*l/5.0 pj=mf*(w-dw)+2.0*l/5.0
ends rnodrpo_m

subckt rpodrpo n1 n2
parameters w=1u l=1u mf=1 rsh=r_rpodrpo dw=0.00u tc1=1.43e-3 tc2=7.82e-7 vc1=-1.19e-3
+ vc2=-1.80e-4 pt=temp tfac=1.0 + tc1 * (pt - 25.0) + tc2 * (pt - 25.0) * (pt
+ - 25.0)
//
R1 (n1 n2) bsource r=(rsh/mf) * (l / (w - dw)) * (1 + vc1 * abs(v(n1,n2)) + vc2 * v(n1,n2)
+ * v(n1,n2)) * tfac
//
ends rpodrpo

subckt rpodrpo_m n2 n1 body
parameters w=1u l=1u mf=1 rsh=r_rpodrpo dw=0.00u tc1=1.43e-3 tc2=7.82e-7 vc1=-1.19e-3
+ vc2=-1.80e-4 pt=temp tfac=1.0 + tc1 * (pt - 25.0) + tc2 * (pt - 25.0) * (pt
+ - 25.0)
R1 (n2 nm n2 n1) bsource r=(rsh/mf) * ((l/4) / (w - dw)) * (1 + vc1 * abs(v(n2,n1)) + vc2 * v(n2,n1) * v(n2,n1)) * tfac
R2 (nm nn n2 n1) bsource r=(rsh/mf) * ((l/4) / (w - dw)) * (1 + vc1 * abs(v(n2,n1)) + vc2 * v(n2,n1) * v(n2,n1)) * tfac
R3 (nn nx n2 n1) bsource r=(rsh/mf) * ((l/4) / (w - dw)) * (1 + vc1 * abs(v(n2,n1)) + vc2 * v(n2,n1) * v(n2,n1)) * tfac
R4 (nx n1 n2 n1) bsource r=(rsh/mf) * ((l/4) / (w - dw)) * (1 + vc1 * abs(v(n2,n1)) + vc2 * v(n2,n1) * v(n2,n1)) * tfac
d1 (n2 body) pdio area=mf*(w-dw)*l/5.0 pj=mf*(w-dw)+2.0*l/5.0
d2 (nm body) pdio area=mf*(w-dw)*l/5.0 pj=mf*2.0*l/5.0
d3 (nn body) pdio area=mf*(w-dw)*l/5.0 pj=mf*2.0*l/5.0
d4 (nx body) pdio area=mf*(w-dw)*l/5.0 pj=mf*2.0*l/5.0
d5 (n1 body) pdio area=mf*(w-dw)*l/5.0 pj=mf*(w-dw)+2.0*l/5.0
ends rpodrpo_m

subckt rnwod n1 n2
parameters w=1u l=1u mf=1 rsh=r_rnwod dw=0.141u tc1=3.68e-3 tc2=9.54e-6 vc1=2.77e-3
+ vc2=2.49e-4 pt=temp tfac=1.0 + tc1 * (pt - 25.0) + tc2 * (pt - 25.0) * (pt
+ - 25.0)
//
R1 (n1 n2) bsource r=(rsh/mf) * (l / (w - dw)) * (1 + vc1 * abs(v(n1,n2)) + vc2 * v(n1,n2)
+ * v(n1,n2)) * tfac
//
ends rnwod

subckt rnwod_m n2 n1 body
parameters w=1u l=1u mf=1 rsh=r_rnwod dw=0.141u tc1=3.68e-3 tc2=9.54e-6 vc1=2.77e-3
+ vc2=2.49e-4 pt=temp tfac=1.0 + tc1 * (pt - 25.0) + tc2 * (pt - 25.0) * (pt
+ - 25.0)
//
R1 (n2 nm n2 n1) bsource r=(rsh/mf) * ((l/4) / (w - dw)) * (1 + vc1 * abs(v(n2,n1)) + vc2 * v(n2,n1) * v(n2,n1)) * tfac
R2 (nm nn n2 n1) bsource r=(rsh/mf) * ((l/4) / (w - dw)) * (1 + vc1 * abs(v(n2,n1)) + vc2 * v(n2,n1) * v(n2,n1)) * tfac
R3 (nn nx n2 n1) bsource r=(rsh/mf) * ((l/4) / (w - dw)) * (1 + vc1 * abs(v(n2,n1)) + vc2 * v(n2,n1) * v(n2,n1)) * tfac
R4 (nx n1 n2 n1) bsource r=(rsh/mf) * ((l/4) / (w - dw)) * (1 + vc1 * abs(v(n2,n1)) + vc2 * v(n2,n1) * v(n2,n1)) * tfac
d1 (body n2) nwdio area=mf*(w-dw)*l/5.0 pj=mf*(w-dw)+2.0*l/5.0
d2 (body nm) nwdio area=mf*(w-dw)*l/5.0 pj=mf*2.0*l/5.0
d3 (body nn) nwdio area=mf*(w-dw)*l/5.0 pj=mf*2.0*l/5.0
d4 (body nx) nwdio area=mf*(w-dw)*l/5.0 pj=mf*2.0*l/5.0
d5 (body n1) nwdio area=mf*(w-dw)*l/5.0 pj=mf*(w-dw)+2.0*l/5.0
//
ends rnwod_m

subckt rnwsti n1 n2
parameters w=1u l=1u mf=1 rsh=r_rnwsti dw=0.182u tc1=2.97e-3 tc2=1.10e-5 vc1=8.06e-3
+ vc2=-3.32e-4 pt=temp tfac=1.0 + tc1 * (pt - 25.0) + tc2 * (pt - 25.0) * (pt
+ - 25.0)
//
R1 (n1 n2) bsource r=(rsh/mf) * (l / (w - dw)) * (1 + vc1 * abs(v(n1,n2)) + vc2 * v(n1,n2)
+ * v(n1,n2)) * tfac
//
ends rnwsti

subckt rnpo1 n1 n2
parameters w=1u l=1u mf=1 rsh=r_rnpo1 dw=-0.057u tc1=2.92e-3 tc2=2.66e-7 vc1=1.35e-3
+ vc2=7.15e-3 pt=temp tfac=1.0 + tc1 * (pt - 25.0) + tc2 * (pt - 25.0) * (pt
+ - 25.0)
//
R1 (n1 n2) bsource r=(rsh/mf) * (l / (w - dw)) * (1 + vc1 * abs(v(n1,n2)) + vc2 * v(n1,n2)
+ * v(n1,n2)) * tfac
//
ends rnpo1

subckt rnpo1w n1 n2
parameters w=1u l=1u mf=1 rsh=r_rnpo1w dw=-0.057u tc1=2.92e-3 tc2=2.66e-7 vc1=1.35e-3
+ vc2=7.15e-3 pt=temp tfac=1.0 + tc1 * (pt - 25.0) + tc2 * (pt - 25.0) * (pt
+ - 25.0)
//
R1 (n1 n2) bsource r=(rsh/mf) * (l / (w - dw)) * (1 + vc1 * abs(v(n1,n2)) + vc2 * v(n1,n2)
+ * v(n1,n2)) * tfac
//
ends rnpo1w

subckt rppo1 n1 n2
parameters w=1u l=1u mf=1 rsh=r_rppo1 dw=-0.025u tc1=2.88e-3 tc2=5.01e-7 vc1=-7.89e-4
+ vc2=6.19e-3 pt=temp tfac=1.0 + tc1 * (pt - 25.0) + tc2 * (pt - 25.0) * (pt
+ - 25.0)
//
R1 (n1 n2) bsource r=(rsh/mf) * (l / (w - dw)) * (1 + vc1 * abs(v(n1,n2)) + vc2 * v(n1,n2)
+ * v(n1,n2)) * tfac
//
ends rppo1

subckt rppo1w n1 n2
parameters w=1u l=1u mf=1 rsh=r_rppo1w dw=-0.025u tc1=2.88e-3 tc2=5.01e-7 vc1=-7.89e-4
+ vc2=6.19e-3 pt=temp tfac=1.0 + tc1 * (pt - 25.0) + tc2 * (pt - 25.0) * (pt
+ - 25.0)
//
R1 (n1 n2) bsource r=(rsh/mf) * (l / (w - dw)) * (1 + vc1 * abs(v(n1,n2)) + vc2 * v(n1,n2)
+ * v(n1,n2)) * tfac
//
ends rppo1w

subckt rnpo1rpo n1 n2
parameters w=1u l=1u mf=1 rc=0 nc=2 rend0=3.2586e-5 rsh=r_rnpo1rpo dl=-0.04225e-6
+ dw=0.091373e-6 pt=temp pvce1=2.7643e3 pvce2=0.0014 pvce3=0.3712 ptce1=-1.372e-3
+ ptce2=-1.680e-5 pvcp1=-0.0187 pvcp2=1.6513e-5 pvcp3=-2.0496 ptcp1=-1.184e-3
+ ptcp2=1.3835e-6 tface=1.0 + ptce1 * (pt - 25.0) + ptce2 * (pt - 25.0) * (pt -
+ 25.0) tfacp=1.0 + ptcp1 * (pt - 25.0) + ptcp2 * (pt - 25.0) * (pt - 25.0)
//
Rend1 (n1 3) bsource r=(rend0/mf/(w - dw)) * (1 + pvce1 * (tanh(pvce2*abs(v(n1,3))+pvce3) - tanh(pvce3))) * tface
Rpure (3  4) bsource r=(rsh/mf) * ((l -dl)/(w - dw)) * (1 + pvcp1 * (tanh(pvcp2*(abs(v(3,4)/(l-dl)))+pvcp3) - tanh(pvcp3))) * tfacp
Rend2 (4 n2) bsource r=(rend0/mf/(w - dw)) * (1 + pvce1 * (tanh(pvce2*abs(v(4,n2))+pvce3) - tanh(pvce3))) * tface
//
ends rnpo1rpo

subckt rppo1rpo n1 n2
parameters w=1u l=1u mf=1 rc=0 nc=2 rend0=7.2135e-5 rsh=r_rppo1rpo dl=0.0006e-6
+ dw=0.06165e-6 pt=temp pvce1=-0.0145 pvce2=62.8187 pvce3=-2.2165 ptce1=-1.692e-3
+ ptce2=-9.616e-6 pvcp1=-0.0011 pvcp2=3.2532e-5 pvcp3=-4.3249 ptcp1=-7.541e-5
+ ptcp2=3.561e-7 tface=1.0 + ptce1 * (pt - 25.0) + ptce2 * (pt - 25.0) * (pt -
+ 25.0) tfacp=1.0 + ptcp1 * (pt - 25.0) + ptcp2 * (pt - 25.0) * (pt - 25.0)
//
Rend1 (n1 3) bsource r=(rend0/mf/(w - dw)) * (1 + pvce1 * (tanh(pvce2*abs(v(n1,3))+pvce3) - tanh(pvce3))) * tface
Rpure (3  4) bsource r=(rsh/mf) * ((l -dl)/(w - dw)) * (1 + pvcp1 * (tanh(pvcp2*(abs(v(3,4)/(l-dl)))+pvcp3) - tanh(pvcp3))) * tfacp
Rend2 (4 n2) bsource r=(rend0/mf/(w - dw)) * (1 + pvce1 * (tanh(pvce2*abs(v(4,n2))+pvce3) - tanh(pvce3))) * tface
//
ends rppo1rpo

subckt rm1 n1 n2
parameters w=1u l=1u mf=1 rsh=r_rm1 dw=0.03u tc1=3.43e-3 tc2=-1.08e-6 vc1=0
+ vc2=0 pt=temp tfac=1.0 + tc1 * (pt - 25.0) + tc2 * (pt - 25.0) * (pt
+ - 25.0)
//
R1 (n1 n2) bsource r=(rsh/mf) * (l / (w - dw)) * (1 + vc1 * abs(v(n1,n2)) + vc2 * v(n1,n2)
+ * v(n1,n2)) * tfac
//
ends rm1

subckt rm2 n1 n2
parameters w=1u l=1u mf=1 rsh=r_rm2 dw=0.03u tc1=3.43e-3 tc2=-1.08e-6 vc1=0
+ vc2=0 pt=temp tfac=1.0 + tc1 * (pt - 25.0) + tc2 * (pt - 25.0) * (pt
+ - 25.0)
//
R1 (n1 n2) bsource r=(rsh/mf) * (l / (w - dw)) * (1 + vc1 * abs(v(n1,n2)) + vc2 * v(n1,n2)
+ * v(n1,n2)) * tfac
//
ends rm2

subckt rm3 n1 n2
parameters w=1u l=1u mf=1 rsh=r_rm3 dw=0.03u tc1=3.43e-3 tc2=-1.08e-6 vc1=0
+ vc2=0 pt=temp tfac=1.0 + tc1 * (pt - 25.0) + tc2 * (pt - 25.0) * (pt
+ - 25.0)
//
R1 (n1 n2) bsource r=(rsh/mf) * (l / (w - dw)) * (1 + vc1 * abs(v(n1,n2)) + vc2 * v(n1,n2)
+ * v(n1,n2)) * tfac
//
ends rm3

subckt rm4 n1 n2
parameters w=1u l=1u mf=1 rsh=r_rm4 dw=0.03u tc1=3.43e-3 tc2=-1.08e-6 vc1=0
+ vc2=0 pt=temp tfac=1.0 + tc1 * (pt - 25.0) + tc2 * (pt - 25.0) * (pt
+ - 25.0)
//
R1 (n1 n2) bsource r=(rsh/mf) * (l / (w - dw)) * (1 + vc1 * abs(v(n1,n2)) + vc2 * v(n1,n2)
+ * v(n1,n2)) * tfac
//
ends rm4

subckt rm5 n1 n2
parameters w=1u l=1u mf=1 rsh=r_rm5 dw=0.03u tc1=3.43e-3 tc2=-1.08e-6 vc1=0
+ vc2=0 pt=temp tfac=1.0 + tc1 * (pt - 25.0) + tc2 * (pt - 25.0) * (pt
+ - 25.0)
//
R1 (n1 n2) bsource r=(rsh/mf) * (l / (w - dw)) * (1 + vc1 * abs(v(n1,n2)) + vc2 * v(n1,n2)
+ * v(n1,n2)) * tfac
//
ends rm5

//
subckt rmt n1 n2
parameters w=1u l=1u mf=1 rsh=r_rmt dw=0.04u tc1=3.60e-3 tc2=-1.16e-7 vc1=0
+ vc2=0 pt=temp tfac=1.0 + tc1 * (pt - 25.0) + tc2 * (pt - 25.0) * (pt
+ - 25.0)
//
R1 (n1 n2) bsource r=(rsh/mf) * (l / (w - dw)) * (1 + vc1 * abs(v(n1,n2)) + vc2 * v(n1,n2)
+ * v(n1,n2)) * tfac
//
ends rmt

subckt rppolyhri n1 n2
parameters w=1u l=1u mf=1 rc=0 nc=2 rend0=4.944e-005 rsh=r_rppolyhri dl=0.145e-007
+ dw=7.382e-008 pt=temp pvce1=-2.909e-001 pvce2=-3.902e+001 pvce3=8.339e-001 ptce1=-2.335e-003
+ ptce2=3.933e-006 pvcp1=-6.353e-002 pvcp2=2.979e-006 pvcp3=-1.486e+000 ptcp1=-1.112e-003
+ ptcp2=2.775e-006 tface=1.0 + ptce1 * (pt - 25.0) + ptce2 * (pt - 25.0) * (pt -
+ 25.0) tfacp=1.0 + ptcp1 * (pt - 25.0) + ptcp2 * (pt - 25.0) * (pt - 25.0)
//
Rend1 (n1 3) bsource r=(rend0/mf/(w - dw)) * (1 + pvce1 * (tanh(pvce2*abs(v(n1,3))+pvce3) - tanh(pvce3))) * tface
Rpure (3  4) bsource r=(rsh/mf) * ((l -dl)/(w - dw)) * (1 + pvcp1 * (tanh(pvcp2*(abs(v(3,4)/(l-dl)))+pvcp3) - tanh(pvcp3))) * tfacp
Rend2 (4 n2) bsource r=(rend0/mf/(w - dw)) * (1 + pvce1 * (tanh(pvce2*abs(v(4,n2))+pvce3) - tanh(pvce3))) * tface
//
ends rppolyhri

//
subckt rnpo1_dis ( n1 n2 gnode )
parameters l=1u w=1u mf=1 rsh=r_rnpo1 dw=-0.057u ptc1=2.92e-3 ptc2=2.66e-7
+ pvc1=1.35e-3 pvc2=7.15e-3 pt=temp tfac=1.0 + ptc1 * (pt - 25.0) + ptc2 * (pt
+ - 25.0) * (pt - 25.0)
r1 ( n1 2 ) bsource r=0.211 * rsh / mf * l / (w - dw) * (1 + pvc1 * abs(v(n1,2))
+ + pvc2 * v(n1,2) * v(n1,2)) * tfac
r2 ( 2 3 ) bsource r=0.578 * rsh / mf * l / (w - dw) * (1 + pvc1 * abs(v(2,3)) +
+ pvc2 * v(2,3) * v(2,3)) * tfac
r3 ( 3 n2 ) bsource r=0.211 * rsh / mf * l / (w - dw) * (1 + pvc1 * abs(v(3,n2))
+ + pvc2 * v(3,n2) * v(3,n2)) * tfac
cox1 ( 2 gnode ) capacitor c=0.5 * (0.0863 * w * (l + 1.08u) * 1e+12 + 0.0373 *
+ 2 * (w + l + 1.08u) * 1e+6) * 1e-15 * mf
cox2 ( 3 gnode ) capacitor c=0.5 * (0.0863 * w * (l + 1.08u) * 1e+12 + 0.0373 *
+ 2 * (w + l + 1.08u) * 1e+6) * 1e-15 * mf
ends rnpo1_dis

subckt rnpo1w_dis ( n1 n2 gnode )
parameters l=1u w=1u mf=1 rsh=r_rnpo1w dw=-0.057u ptc1=2.92e-3 ptc2=2.66e-7
+ pvc1=1.35e-3 pvc2=7.15e-3 pt=temp tfac=1.0 + ptc1 * (pt - 25.0) + ptc2 * (pt
+ - 25.0) * (pt - 25.0)
r1 ( n1 2 ) bsource r=0.211 * rsh / mf * l / (w - dw) * (1 + pvc1 * abs(v(n1,2))
+ + pvc2 * v(n1,2) * v(n1,2)) * tfac
r2 ( 2 3 ) bsource r=0.578 * rsh / mf * l / (w - dw) * (1 + pvc1 * abs(v(2,3)) +
+ pvc2 * v(2,3) * v(2,3)) * tfac
r3 ( 3 n2 ) bsource r=0.211 * rsh / mf * l / (w - dw) * (1 + pvc1 * abs(v(3,n2))
+ + pvc2 * v(3,n2) * v(3,n2)) * tfac
cox1 ( 2 gnode ) capacitor c=0.5 * (0.0863 * w * (l + 1.08u) * 1e+12 + 0.0373 *
+ 2 * (w + l + 1.08u) * 1e+6) * 1e-15 * mf
cox2 ( 3 gnode ) capacitor c=0.5 * (0.0863 * w * (l + 1.08u) * 1e+12 + 0.0373 *
+ 2 * (w + l + 1.08u) * 1e+6) * 1e-15 * mf
ends rnpo1w_dis

subckt rppo1_dis ( n1 n2 gnode )
parameters l=1u w=1u mf=1 rsh=r_rppo1 dw=-0.025u ptc1=2.88e-3 ptc2=5.01e-7
+ pvc1=-7.89e-4 pvc2=6.19e-3 pt=temp tfac=1.0 + ptc1 * (pt - 25.0) + ptc2 * (pt
+ - 25.0) * (pt - 25.0)
r1 ( n1 2 ) bsource r=0.211 * rsh / mf * l / (w - dw) * (1 + pvc1 * abs(v(n1,2))
+ + pvc2 * v(n1,2) * v(n1,2)) * tfac
r2 ( 2 3 ) bsource r=0.578 * rsh / mf * l / (w - dw) * (1 + pvc1 * abs(v(2,3)) +
+ pvc2 * v(2,3) * v(2,3)) * tfac
r3 ( 3 n2 ) bsource r=0.211 * rsh / mf * l / (w - dw) * (1 + pvc1 * abs(v(3,n2))
+ + pvc2 * v(3,n2) * v(3,n2)) * tfac
cox1 ( 2 gnode ) capacitor c=0.5 * (0.0863 * w * (l + 1.08u) * 1e+12 + 0.0373 *
+ 2 * (w + l + 1.08u) * 1e+6) * 1e-15 * mf
cox2 ( 3 gnode ) capacitor c=0.5 * (0.0863 * w * (l + 1.08u) * 1e+12 + 0.0373 *
+ 2 * (w + l + 1.08u) * 1e+6) * 1e-15 * mf
ends rppo1_dis

subckt rppo1w_dis ( n1 n2 gnode )
parameters l=1u w=1u mf=1 rsh=r_rppo1w dw=-0.025u ptc1=2.88e-3 ptc2=5.01e-7
+ pvc1=-7.89e-4 pvc2=6.19e-3 pt=temp tfac=1.0 + ptc1 * (pt - 25.0) + ptc2 * (pt
+ - 25.0) * (pt - 25.0)
r1 ( n1 2 ) bsource r=0.211 * rsh / mf * l / (w - dw) * (1 + pvc1 * abs(v(n1,2))
+ + pvc2 * v(n1,2) * v(n1,2)) * tfac
r2 ( 2 3 ) bsource r=0.578 * rsh / mf * l / (w - dw) * (1 + pvc1 * abs(v(2,3)) +
+ pvc2 * v(2,3) * v(2,3)) * tfac
r3 ( 3 n2 ) bsource r=0.211 * rsh / mf * l / (w - dw) * (1 + pvc1 * abs(v(3,n2))
+ + pvc2 * v(3,n2) * v(3,n2)) * tfac
cox1 ( 2 gnode ) capacitor c=0.5 * (0.0863 * w * (l + 1.08u) * 1e+12 + 0.0373 *
+ 2 * (w + l + 1.08u) * 1e+6) * 1e-15 * mf
cox2 ( 3 gnode ) capacitor c=0.5 * (0.0863 * w * (l + 1.08u) * 1e+12 + 0.0373 *
+ 2 * (w + l + 1.08u) * 1e+6) * 1e-15 * mf
ends rppo1w_dis

subckt rnpo1rpo_dis ( n1 n2 gnode )
parameters l=1u w=1u mf=1 rend0=3.2586e-5 rsh=r_rnpo1rpo dl=-0.04225e-6 dw=0.091373e-6
+ pt=temp pvce1=2.7643e3 pvce2=0.0014 pvce3=0.3712 ptce1=-1.372e-3 ptce2=-1.680e-5
+ pvcp1=-0.0187 pvcp2=1.6513e-5 pvcp3=-2.0496 ptcp1=-1.184e-3 ptcp2=1.3835e-6 tface=1.0
+ + ptce1 * (pt - 25.0) + ptce2 * (pt - 25.0) * (pt - 25.0) tfacp=1.0 + ptcp1 *
+ (pt - 25.0) + ptcp2 * (pt - 25.0) * (pt - 25.0)
rend1 ( n1 1 ) bsource r=rend0 / mf / (w - dw) * tface * (1 + pvce1 * (tanh(pvce2
+ * abs(v(n1,1)) + pvce3) - tanh(pvce3)))
rpure1 ( 1 2 ) bsource r=0.211 * rsh / mf * (l - dl) / (w - dw) * tfacp * (1 + pvcp1
+ * (tanh(pvcp2 * abs(v(1,2) / (l - dl)) + pvcp3) - tanh(pvcp3)))
rpure2 ( 2 3 ) bsource r=0.578 * rsh / mf * (l - dl) / (w - dw) * tfacp * (1 + pvcp1
+ * (tanh(pvcp2 * abs(v(2,3) / (l - dl)) + pvcp3) - tanh(pvcp3)))
rpure3 ( 3 4 ) bsource r=0.211 * rsh / mf * (l - dl) / (w - dw) * tfacp * (1 + pvcp1
+ * (tanh(pvcp2 * abs(v(3,4) / (l - dl)) + pvcp3) - tanh(pvcp3)))
rend2 ( 4 n2 ) bsource r=rend0 / mf / (w - dw) * tface * (1 + pvce1 * (tanh(pvce2
+ * abs(v(4,n2)) + pvce3) - tanh(pvce3)))
cox1 ( 2 gnode ) capacitor c=0.5 * (0.0863 * w * (l + 1.08u) * 1e+12 + 0.0373 *
+ 2 * (w + l + 1.08u) * 1e+6) * 1e-15 * mf
cox2 ( 3 gnode ) capacitor c=0.5 * (0.0863 * w * (l + 1.08u) * 1e+12 + 0.0373 *
+ 2 * (w + l + 1.08u) * 1e+6) * 1e-15 * mf
ends rnpo1rpo_dis

subckt rppo1rpo_dis ( n1 n2 gnode )
parameters l=1u w=1u mf=1 rend0=7.2135e-5 rsh=r_rppo1rpo dl=0.0006e-6 dw=0.06165e-6
+ pt=temp pvce1=-0.0145 pvce2=62.8187 pvce3=-2.2165 ptce1=-1.692e-3 ptce2=-9.616e-6
+ pvcp1=-0.0011 pvcp2=3.2532e-5 pvcp3=-4.3249 ptcp1=-7.541e-5 ptcp2=3.561e-7 tface=1.0
+ + ptce1 * (pt - 25.0) + ptce2 * (pt - 25.0) * (pt - 25.0) tfacp=1.0 + ptcp1 *
+ (pt - 25.0) + ptcp2 * (pt - 25.0) * (pt - 25.0)
rend1 ( n1 1 ) bsource r=rend0 / mf / (w - dw) * tface * (1 + pvce1 * (tanh(pvce2
+ * abs(v(n1,1)) + pvce3) - tanh(pvce3)))
rpure1 ( 1 2 ) bsource r=0.211 * rsh / mf * (l - dl) / (w - dw) * tfacp * (1 + pvcp1
+ * (tanh(pvcp2 * abs(v(1,2) / (l - dl)) + pvcp3) - tanh(pvcp3)))
rpure2 ( 2 3 ) bsource r=0.578 * rsh / mf * (l - dl) / (w - dw) * tfacp * (1 + pvcp1
+ * (tanh(pvcp2 * abs(v(2,3) / (l - dl)) + pvcp3) - tanh(pvcp3)))
rpure3 ( 3 4 ) bsource r=0.211 * rsh / mf * (l - dl) / (w - dw) * tfacp * (1 + pvcp1
+ * (tanh(pvcp2 * abs(v(3,4) / (l - dl)) + pvcp3) - tanh(pvcp3)))
rend2 ( 4 n2 ) bsource r=rend0 / mf / (w - dw) * tface * (1 + pvce1 * (tanh(pvce2
+ * abs(v(4,n2)) + pvce3) - tanh(pvce3)))
cox1 ( 2 gnode ) capacitor c=0.5 * (0.0863 * w * (l + 1.08u) * 1e+12 + 0.0373 *
+ 2 * (w + l + 1.08u) * 1e+6) * 1e-15 * mf
cox2 ( 3 gnode ) capacitor c=0.5 * (0.0863 * w * (l + 1.08u) * 1e+12 + 0.0373 *
+ 2 * (w + l + 1.08u) * 1e+6) * 1e-15 * mf
ends rppo1rpo_dis

subckt rppolyhri_dis ( n1 n2 gnode )
parameters l=1u w=1u mf=1 rend0=4.944e-005 rsh=r_rppolyhri dl=0.145e-007
+ dw=7.382e-008 pt=temp pvce1=-2.909e-001 pvce2=-3.902e+001 pvce3=8.339e-001 ptce1=-2.335e-003
+ ptce2=3.933e-006 pvcp1=-6.353e-002 pvcp2=2.979e-006 pvcp3=-1.486e+000 ptcp1=-1.112e-003
+ ptcp2=2.775e-006 tface=1.0 + ptce1 * (pt - 25.0) + ptce2 * (pt - 25.0) * (pt -
+ 25.0) tfacp=1.0 + ptcp1 * (pt - 25.0) + ptcp2 * (pt - 25.0) * (pt - 25.0)
rend1 ( n1 1 ) bsource r=rend0 / mf / (w - dw) * tface * (1 + pvce1 * (tanh(pvce2
+ * abs(v(n1,1)) + pvce3) - tanh(pvce3)))
rpure1 ( 1 2 ) bsource r=0.211 * rsh / mf * (l - dl) / (w - dw) * tfacp * (1 + pvcp1
+ * (tanh(pvcp2 * abs(v(1,2) / (l - dl)) + pvcp3) - tanh(pvcp3)))
rpure2 ( 2 3 ) bsource r=0.578 * rsh / mf * (l - dl) / (w - dw) * tfacp * (1 + pvcp1
+ * (tanh(pvcp2 * abs(v(2,3) / (l - dl)) + pvcp3) - tanh(pvcp3)))
rpure3 ( 3 4 ) bsource r=0.211 * rsh / mf * (l - dl) / (w - dw) * tfacp * (1 + pvcp1
+ * (tanh(pvcp2 * abs(v(3,4) / (l - dl)) + pvcp3) - tanh(pvcp3)))
rend2 ( 4 n2 ) bsource r=rend0 / mf / (w - dw) * tface * (1 + pvce1 * (tanh(pvce2
+ * abs(v(4,n2)) + pvce3) - tanh(pvce3)))
cox1 ( 2 gnode ) capacitor c=0.5 * (0.0863 * w * (l + 1.08u) * 1e+12 + 0.0373 *
+ 2 * (w + l + 1.08u) * 1e+6) * 1e-15 * mf
cox2 ( 3 gnode ) capacitor c=0.5 * (0.0863 * w * (l + 1.08u) * 1e+12 + 0.0373 *
+ 2 * (w + l + 1.08u) * 1e+6) * 1e-15 * mf
ends rppolyhri_dis

endsection res

//*************************************************************************
//*         MiM capacitance Model                                         *
//*************************************************************************

section tt_mim
parameters mimfac=1
include "rf018.scs" section=mim
endsection tt_mim

section ss_mim
parameters mimfac=1.15
include "rf018.scs" section=mim
endsection ss_mim

section ff_mim
parameters mimfac=0.85
include "rf018.scs" section=mim
endsection ff_mim

section mim
//ahdl_include "rmim_va.va"
//
subckt mimcap n1 n2
parameters w=1u l=1u
+ cmim_para=(w * l ) * 1.025e-3 + 2 * (w + l)* 2.425E-10
//
model cmim_cap capacitor c=1.0f coeffs=[6.16e-5 -2.05e-5] tc1=-5.225e-5 tc2=1.00e-8 tnom=25
C1 (n1 n2) cmim_cap c=cmim_para*mimfac
//
ends mimcap
//
endsection mim

//  ******************************************************
//  ***** Baseband MOS Varactor Corner Parameters ********
//  ******************************************************

section tt_bbmvar
parameters cmv_bbmvarfac=1.0
include "rf018.scs" section=bb_mvar
endsection tt_bbmvar

section ff_bbmvar
parameters cmv_bbmvarfac=0.9556
include "rf018.scs" section=bb_mvar
endsection ff_bbmvar

section ss_bbmvar
parameters cmv_bbmvarfac=1.0444
include "rf018.scs" section=bb_mvar
endsection ss_bbmvar

section bb_mvar

//  ************************************************************************
//                                                                         *
//                  1.8V IO NMOS in N-Well varactor MODEL                  *
//                                                                         *
//  ************************************************************************
subckt nmoscap ( ng nds )
parameters lr=1e-6 wr=1e-6 mr=1 area=lr * wr * mr pj=2 * wr * mr dt=temp
+ - 25 cgmin=(3.727e-10 * pj + 2.008e-03 * area) * (1 + 4.84e-5 * dt + 8.53e-7 *
+ dt * dt) dcg=( - 2.42e-11 * pj + 3.298e-03 * area) * (1 - 8.303e-5 * dt - 2.889e-7
+ * dt * dt) dvgs= - 0.08179 - 1.531e-04 * dt vgnorm=0.3939 + 5.273e-04 * dt
cg ( ng nds ) bsource q=((cgmin+dcg)*v(ng,nds)+vgnorm*dcg*log(cosh((v(ng,nds)-dvgs)/vgnorm))) * cmv_bbmvarfac
ends nmoscap

//  ************************************************************************
//                                                                         *
//                  3.3V IO NMOS in N-Well varactor MODEL                  *
//                                                                         *
//  ************************************************************************
subckt nmoscap_33 ( ng nds )
parameters lr=1e-6 wr=1e-6 mr=1 area=lr * wr * mr pj=2 * wr * mr dt=temp
+ - 25 cgmin=(3.334e-10 * pj + 1.549e-03 * area) * (1 + 3.001e-4 * dt + 6.033e-6
+ * dt ** 2) dcg=( - 1.655e-11 * pj + 1.769e-03 * area) * (1 - 2.486e-4 * dt - 2.636e-6
+ * dt ** 2) dvgs= - 0.2032 + 3.961e-05 * dt vgnorm=0.635 + 1.755e-04 * dt
cg ( ng nds ) bsource q=((cgmin+dcg)*v(ng,nds)+vgnorm*dcg*log(cosh((v(ng,nds)-dvgs)/vgnorm))) * cmv_bbmvarfac
ends nmoscap_33

endsection bb_mvar
endlibrary tsmclib
